* SPICE3 file created from top.ext - technology: scmos

.option scale=0.3u

M1000 DFFNEGX1_51/a_76_6# BUFX2_4/Y DFFNEGX1_51/a_66_6# Gnd nfet w=10 l=2
+  ad=14.999999p pd=13u as=40p ps=18u
M1001 gnd BUFX2_4/Y DFFNEGX1_51/a_2_6# Gnd nfet w=20 l=2
+  ad=55p pd=26u as=100p ps=50u
M1002 DFFNEGX1_51/a_66_6# DFFNEGX1_51/a_2_6# DFFNEGX1_51/a_61_6# Gnd nfet w=10 l=2
+  ad=40p pd=18u as=14.999999p ps=13u
M1003 invader_1_coord_y[3] DFFNEGX1_51/a_66_6# gnd Gnd nfet w=20 l=2
+  ad=100p pd=50u as=55p ps=26u
M1004 DFFNEGX1_51/a_23_6# BUFX2_4/Y DFFNEGX1_51/a_17_6# Gnd nfet w=10 l=2
+  ad=29.999998p pd=16u as=20p ps=14u
M1005 DFFNEGX1_51/a_23_6# DFFNEGX1_51/a_2_6# DFFNEGX1_51/a_17_74# vdd pfet w=20 l=2
+  ad=59.999996p pd=26u as=40p ps=24u
M1006 gnd DFFNEGX1_51/a_34_4# DFFNEGX1_51/a_31_6# Gnd nfet w=10 l=2
+  ad=35p pd=17u as=14.999999p ps=13u
M1007 vdd DFFNEGX1_51/a_34_4# DFFNEGX1_51/a_31_74# vdd pfet w=20 l=2
+  ad=59.999996p pd=26u as=40p ps=24u
M1008 DFFNEGX1_51/a_61_74# DFFNEGX1_51/a_34_4# vdd vdd pfet w=20 l=2
+  ad=29.999998p pd=23u as=100p ps=50u
M1009 DFFNEGX1_51/a_34_4# DFFNEGX1_51/a_23_6# vdd vdd pfet w=20 l=2
+  ad=100p pd=50u as=59.999996p ps=26u
M1010 DFFNEGX1_51/a_34_4# DFFNEGX1_51/a_23_6# gnd Gnd nfet w=10 l=2
+  ad=50p pd=30u as=35p ps=17u
M1011 vdd invader_1_coord_y[3] DFFNEGX1_51/a_76_84# vdd pfet w=10 l=2
+  ad=0.105n pd=46u as=14.999999p ps=13u
M1012 gnd invader_1_coord_y[3] DFFNEGX1_51/a_76_6# Gnd nfet w=10 l=2
+  ad=55p pd=26u as=14.999999p ps=13u
M1013 DFFNEGX1_51/a_61_6# DFFNEGX1_51/a_34_4# gnd Gnd nfet w=10 l=2
+  ad=14.999999p pd=13u as=50p ps=30u
M1014 DFFNEGX1_51/a_76_84# DFFNEGX1_51/a_2_6# DFFNEGX1_51/a_66_6# vdd pfet w=10 l=2
+  ad=14.999999p pd=13u as=75p ps=28u
M1015 invader_1_coord_y[3] DFFNEGX1_51/a_66_6# vdd vdd pfet w=40 l=2
+  ad=0.2n pd=90u as=0.105n ps=46u
M1016 vdd BUFX2_4/Y DFFNEGX1_51/a_2_6# vdd pfet w=40 l=2
+  ad=0.11n pd=46u as=0.2n ps=90u
M1017 DFFNEGX1_51/a_31_6# DFFNEGX1_51/a_2_6# DFFNEGX1_51/a_23_6# Gnd nfet w=10 l=2
+  ad=14.999999p pd=13u as=29.999998p ps=16u
M1018 DFFNEGX1_51/a_66_6# BUFX2_4/Y DFFNEGX1_51/a_61_74# vdd pfet w=20 l=2
+  ad=75p pd=28u as=29.999998p ps=23u
M1019 DFFNEGX1_51/a_17_74# NAND3X1_28/Y vdd vdd pfet w=20 l=2
+  ad=40p pd=24u as=0.11n ps=46u
M1020 DFFNEGX1_51/a_31_74# BUFX2_4/Y DFFNEGX1_51/a_23_6# vdd pfet w=20 l=2
+  ad=40p pd=24u as=59.999996p ps=26u
M1021 DFFNEGX1_51/a_17_6# NAND3X1_28/Y gnd Gnd nfet w=10 l=2
+  ad=20p pd=14u as=55p ps=26u
M1022 DFFNEGX1_40/a_76_6# BUFX2_5/Y DFFNEGX1_40/a_66_6# Gnd nfet w=10 l=2
+  ad=29.999998p pd=26u as=80p ps=36u
M1023 gnd BUFX2_5/Y DFFNEGX1_40/a_2_6# Gnd nfet w=20 l=2
+  ad=0.129304u pd=0.062646 as=100p ps=50u
M1024 DFFNEGX1_40/a_66_6# DFFNEGX1_40/a_2_6# DFFNEGX1_40/a_61_6# Gnd nfet w=10 l=2
+  ad=0 pd=0 as=29.999998p ps=26u
M1025 invader_1_coord_y[0] DFFNEGX1_40/a_66_6# gnd Gnd nfet w=20 l=2
+  ad=100p pd=50u as=0 ps=0
M1026 DFFNEGX1_40/a_23_6# BUFX2_5/Y DFFNEGX1_40/a_17_6# Gnd nfet w=10 l=2
+  ad=59.999996p pd=32u as=40p ps=28u
M1027 DFFNEGX1_40/a_23_6# DFFNEGX1_40/a_2_6# DFFNEGX1_40/a_17_74# vdd pfet w=20 l=2
+  ad=0.12n pd=52u as=80p ps=48u
M1028 gnd DFFNEGX1_40/a_34_4# DFFNEGX1_40/a_31_6# Gnd nfet w=10 l=2
+  ad=0 pd=0 as=29.999998p ps=26u
M1029 vdd DFFNEGX1_40/a_34_4# DFFNEGX1_40/a_31_74# vdd pfet w=20 l=2
+  ad=0.253016u pd=0.111328 as=80p ps=48u
M1030 DFFNEGX1_40/a_61_74# DFFNEGX1_40/a_34_4# vdd vdd pfet w=20 l=2
+  ad=59.999996p pd=46u as=0 ps=0
M1031 DFFNEGX1_40/a_34_4# DFFNEGX1_40/a_23_6# vdd vdd pfet w=20 l=2
+  ad=100p pd=50u as=0 ps=0
M1032 DFFNEGX1_40/a_34_4# DFFNEGX1_40/a_23_6# gnd Gnd nfet w=10 l=2
+  ad=50p pd=30u as=0 ps=0
M1033 vdd invader_1_coord_y[0] DFFNEGX1_40/a_76_84# vdd pfet w=10 l=2
+  ad=0 pd=0 as=29.999998p ps=26u
M1034 gnd invader_1_coord_y[0] DFFNEGX1_40/a_76_6# Gnd nfet w=10 l=2
+  ad=0 pd=0 as=0 ps=0
M1035 DFFNEGX1_40/a_61_6# DFFNEGX1_40/a_34_4# gnd Gnd nfet w=10 l=2
+  ad=0 pd=0 as=0 ps=0
M1036 DFFNEGX1_40/a_76_84# DFFNEGX1_40/a_2_6# DFFNEGX1_40/a_66_6# vdd pfet w=10 l=2
+  ad=0 pd=0 as=0.15n ps=56u
M1037 invader_1_coord_y[0] DFFNEGX1_40/a_66_6# vdd vdd pfet w=40 l=2
+  ad=0.2n pd=90u as=0 ps=0
M1038 vdd BUFX2_5/Y DFFNEGX1_40/a_2_6# vdd pfet w=40 l=2
+  ad=0 pd=0 as=0.2n ps=90u
M1039 DFFNEGX1_40/a_31_6# DFFNEGX1_40/a_2_6# DFFNEGX1_40/a_23_6# Gnd nfet w=10 l=2
+  ad=0 pd=0 as=0 ps=0
M1040 DFFNEGX1_40/a_66_6# BUFX2_5/Y DFFNEGX1_40/a_61_74# vdd pfet w=20 l=2
+  ad=0 pd=0 as=0 ps=0
M1041 DFFNEGX1_40/a_17_74# OR2X1_10/Y vdd vdd pfet w=20 l=2
+  ad=0 pd=0 as=0 ps=0
M1042 DFFNEGX1_40/a_31_74# BUFX2_5/Y DFFNEGX1_40/a_23_6# vdd pfet w=20 l=2
+  ad=0 pd=0 as=0 ps=0
M1043 DFFNEGX1_40/a_17_6# OR2X1_10/Y gnd Gnd nfet w=10 l=2
+  ad=0 pd=0 as=0 ps=0
M1044 DFFNEGX1_62/a_76_6# BUFX2_3/Y DFFNEGX1_62/a_66_6# Gnd nfet w=10 l=2
+  ad=29.999998p pd=26u as=80p ps=36u
M1045 gnd BUFX2_3/Y DFFNEGX1_62/a_2_6# Gnd nfet w=20 l=2
+  ad=0 pd=0 as=100p ps=50u
M1046 DFFNEGX1_62/a_66_6# DFFNEGX1_62/a_2_6# DFFNEGX1_62/a_61_6# Gnd nfet w=10 l=2
+  ad=0 pd=0 as=29.999998p ps=26u
M1047 shield_coord_x[2] DFFNEGX1_62/a_66_6# gnd Gnd nfet w=20 l=2
+  ad=100p pd=50u as=0 ps=0
M1048 DFFNEGX1_62/a_23_6# BUFX2_3/Y DFFNEGX1_62/a_17_6# Gnd nfet w=10 l=2
+  ad=59.999996p pd=32u as=40p ps=28u
M1049 DFFNEGX1_62/a_23_6# DFFNEGX1_62/a_2_6# DFFNEGX1_62/a_17_74# vdd pfet w=20 l=2
+  ad=0.12n pd=52u as=80p ps=48u
M1050 gnd DFFNEGX1_62/a_34_4# DFFNEGX1_62/a_31_6# Gnd nfet w=10 l=2
+  ad=0 pd=0 as=29.999998p ps=26u
M1051 vdd DFFNEGX1_62/a_34_4# DFFNEGX1_62/a_31_74# vdd pfet w=20 l=2
+  ad=0 pd=0 as=80p ps=48u
M1052 DFFNEGX1_62/a_61_74# DFFNEGX1_62/a_34_4# vdd vdd pfet w=20 l=2
+  ad=59.999996p pd=46u as=0 ps=0
M1053 DFFNEGX1_62/a_34_4# DFFNEGX1_62/a_23_6# vdd vdd pfet w=20 l=2
+  ad=100p pd=50u as=0 ps=0
M1054 DFFNEGX1_62/a_34_4# DFFNEGX1_62/a_23_6# gnd Gnd nfet w=10 l=2
+  ad=50p pd=30u as=0 ps=0
M1055 vdd shield_coord_x[2] DFFNEGX1_62/a_76_84# vdd pfet w=10 l=2
+  ad=0 pd=0 as=29.999998p ps=26u
M1056 gnd shield_coord_x[2] DFFNEGX1_62/a_76_6# Gnd nfet w=10 l=2
+  ad=0 pd=0 as=0 ps=0
M1057 DFFNEGX1_62/a_61_6# DFFNEGX1_62/a_34_4# gnd Gnd nfet w=10 l=2
+  ad=0 pd=0 as=0 ps=0
M1058 DFFNEGX1_62/a_76_84# DFFNEGX1_62/a_2_6# DFFNEGX1_62/a_66_6# vdd pfet w=10 l=2
+  ad=0 pd=0 as=0.15n ps=56u
M1059 shield_coord_x[2] DFFNEGX1_62/a_66_6# vdd vdd pfet w=40 l=2
+  ad=0.2n pd=90u as=0 ps=0
M1060 vdd BUFX2_3/Y DFFNEGX1_62/a_2_6# vdd pfet w=40 l=2
+  ad=0 pd=0 as=0.2n ps=90u
M1061 DFFNEGX1_62/a_31_6# DFFNEGX1_62/a_2_6# DFFNEGX1_62/a_23_6# Gnd nfet w=10 l=2
+  ad=0 pd=0 as=0 ps=0
M1062 DFFNEGX1_62/a_66_6# BUFX2_3/Y DFFNEGX1_62/a_61_74# vdd pfet w=20 l=2
+  ad=0 pd=0 as=0 ps=0
M1063 DFFNEGX1_62/a_17_74# OAI21X1_95/Y vdd vdd pfet w=20 l=2
+  ad=0 pd=0 as=0 ps=0
M1064 DFFNEGX1_62/a_31_74# BUFX2_3/Y DFFNEGX1_62/a_23_6# vdd pfet w=20 l=2
+  ad=0 pd=0 as=0 ps=0
M1065 DFFNEGX1_62/a_17_6# OAI21X1_95/Y gnd Gnd nfet w=10 l=2
+  ad=0 pd=0 as=0 ps=0
M1066 DFFNEGX1_73/a_76_6# BUFX2_3/Y DFFNEGX1_73/a_66_6# Gnd nfet w=10 l=2
+  ad=29.999998p pd=26u as=80p ps=36u
M1067 gnd BUFX2_3/Y DFFNEGX1_73/a_2_6# Gnd nfet w=20 l=2
+  ad=0 pd=0 as=100p ps=50u
M1068 DFFNEGX1_73/a_66_6# DFFNEGX1_73/a_2_6# DFFNEGX1_73/a_61_6# Gnd nfet w=10 l=2
+  ad=0 pd=0 as=29.999998p ps=26u
M1069 player_coord_x[3] DFFNEGX1_73/a_66_6# gnd Gnd nfet w=20 l=2
+  ad=100p pd=50u as=0 ps=0
M1070 DFFNEGX1_73/a_23_6# BUFX2_3/Y DFFNEGX1_73/a_17_6# Gnd nfet w=10 l=2
+  ad=59.999996p pd=32u as=40p ps=28u
M1071 DFFNEGX1_73/a_23_6# DFFNEGX1_73/a_2_6# DFFNEGX1_73/a_17_74# vdd pfet w=20 l=2
+  ad=0.12n pd=52u as=80p ps=48u
M1072 gnd DFFNEGX1_73/a_34_4# DFFNEGX1_73/a_31_6# Gnd nfet w=10 l=2
+  ad=0 pd=0 as=29.999998p ps=26u
M1073 vdd DFFNEGX1_73/a_34_4# DFFNEGX1_73/a_31_74# vdd pfet w=20 l=2
+  ad=0 pd=0 as=80p ps=48u
M1074 DFFNEGX1_73/a_61_74# DFFNEGX1_73/a_34_4# vdd vdd pfet w=20 l=2
+  ad=59.999996p pd=46u as=0 ps=0
M1075 DFFNEGX1_73/a_34_4# DFFNEGX1_73/a_23_6# vdd vdd pfet w=20 l=2
+  ad=100p pd=50u as=0 ps=0
M1076 DFFNEGX1_73/a_34_4# DFFNEGX1_73/a_23_6# gnd Gnd nfet w=10 l=2
+  ad=50p pd=30u as=0 ps=0
M1077 vdd player_coord_x[3] DFFNEGX1_73/a_76_84# vdd pfet w=10 l=2
+  ad=0 pd=0 as=29.999998p ps=26u
M1078 gnd player_coord_x[3] DFFNEGX1_73/a_76_6# Gnd nfet w=10 l=2
+  ad=0 pd=0 as=0 ps=0
M1079 DFFNEGX1_73/a_61_6# DFFNEGX1_73/a_34_4# gnd Gnd nfet w=10 l=2
+  ad=0 pd=0 as=0 ps=0
M1080 DFFNEGX1_73/a_76_84# DFFNEGX1_73/a_2_6# DFFNEGX1_73/a_66_6# vdd pfet w=10 l=2
+  ad=0 pd=0 as=0.15n ps=56u
M1081 player_coord_x[3] DFFNEGX1_73/a_66_6# vdd vdd pfet w=40 l=2
+  ad=0.2n pd=90u as=0 ps=0
M1082 vdd BUFX2_3/Y DFFNEGX1_73/a_2_6# vdd pfet w=40 l=2
+  ad=0 pd=0 as=0.2n ps=90u
M1083 DFFNEGX1_73/a_31_6# DFFNEGX1_73/a_2_6# DFFNEGX1_73/a_23_6# Gnd nfet w=10 l=2
+  ad=0 pd=0 as=0 ps=0
M1084 DFFNEGX1_73/a_66_6# BUFX2_3/Y DFFNEGX1_73/a_61_74# vdd pfet w=20 l=2
+  ad=0 pd=0 as=0 ps=0
M1085 DFFNEGX1_73/a_17_74# OAI21X1_102/Y vdd vdd pfet w=20 l=2
+  ad=0 pd=0 as=0 ps=0
M1086 DFFNEGX1_73/a_31_74# BUFX2_3/Y DFFNEGX1_73/a_23_6# vdd pfet w=20 l=2
+  ad=0 pd=0 as=0 ps=0
M1087 DFFNEGX1_73/a_17_6# OAI21X1_102/Y gnd Gnd nfet w=10 l=2
+  ad=0 pd=0 as=0 ps=0
M1088 DFFNEGX1_84/a_76_6# BUFX2_2/Y DFFNEGX1_84/a_66_6# Gnd nfet w=10 l=2
+  ad=29.999998p pd=26u as=80p ps=36u
M1089 gnd BUFX2_2/Y DFFNEGX1_84/a_2_6# Gnd nfet w=20 l=2
+  ad=0 pd=0 as=100p ps=50u
M1090 DFFNEGX1_84/a_66_6# DFFNEGX1_84/a_2_6# DFFNEGX1_84/a_61_6# Gnd nfet w=10 l=2
+  ad=0 pd=0 as=29.999998p ps=26u
M1091 INVX2_153/A DFFNEGX1_84/a_66_6# gnd Gnd nfet w=20 l=2
+  ad=100p pd=50u as=0 ps=0
M1092 DFFNEGX1_84/a_23_6# BUFX2_2/Y DFFNEGX1_84/a_17_6# Gnd nfet w=10 l=2
+  ad=59.999996p pd=32u as=40p ps=28u
M1093 DFFNEGX1_84/a_23_6# DFFNEGX1_84/a_2_6# DFFNEGX1_84/a_17_74# vdd pfet w=20 l=2
+  ad=0.12n pd=52u as=80p ps=48u
M1094 gnd DFFNEGX1_84/a_34_4# DFFNEGX1_84/a_31_6# Gnd nfet w=10 l=2
+  ad=0 pd=0 as=29.999998p ps=26u
M1095 vdd DFFNEGX1_84/a_34_4# DFFNEGX1_84/a_31_74# vdd pfet w=20 l=2
+  ad=0 pd=0 as=80p ps=48u
M1096 DFFNEGX1_84/a_61_74# DFFNEGX1_84/a_34_4# vdd vdd pfet w=20 l=2
+  ad=59.999996p pd=46u as=0 ps=0
M1097 DFFNEGX1_84/a_34_4# DFFNEGX1_84/a_23_6# vdd vdd pfet w=20 l=2
+  ad=100p pd=50u as=0 ps=0
M1098 DFFNEGX1_84/a_34_4# DFFNEGX1_84/a_23_6# gnd Gnd nfet w=10 l=2
+  ad=50p pd=30u as=0 ps=0
M1099 vdd INVX2_153/A DFFNEGX1_84/a_76_84# vdd pfet w=10 l=2
+  ad=0 pd=0 as=29.999998p ps=26u
M1100 gnd INVX2_153/A DFFNEGX1_84/a_76_6# Gnd nfet w=10 l=2
+  ad=0 pd=0 as=0 ps=0
M1101 DFFNEGX1_84/a_61_6# DFFNEGX1_84/a_34_4# gnd Gnd nfet w=10 l=2
+  ad=0 pd=0 as=0 ps=0
M1102 DFFNEGX1_84/a_76_84# DFFNEGX1_84/a_2_6# DFFNEGX1_84/a_66_6# vdd pfet w=10 l=2
+  ad=0 pd=0 as=0.15n ps=56u
M1103 INVX2_153/A DFFNEGX1_84/a_66_6# vdd vdd pfet w=40 l=2
+  ad=0.2n pd=90u as=0 ps=0
M1104 vdd BUFX2_2/Y DFFNEGX1_84/a_2_6# vdd pfet w=40 l=2
+  ad=0 pd=0 as=0.2n ps=90u
M1105 DFFNEGX1_84/a_31_6# DFFNEGX1_84/a_2_6# DFFNEGX1_84/a_23_6# Gnd nfet w=10 l=2
+  ad=0 pd=0 as=0 ps=0
M1106 DFFNEGX1_84/a_66_6# BUFX2_2/Y DFFNEGX1_84/a_61_74# vdd pfet w=20 l=2
+  ad=0 pd=0 as=0 ps=0
M1107 DFFNEGX1_84/a_17_74# OAI21X1_126/Y vdd vdd pfet w=20 l=2
+  ad=0 pd=0 as=0 ps=0
M1108 DFFNEGX1_84/a_31_74# BUFX2_2/Y DFFNEGX1_84/a_23_6# vdd pfet w=20 l=2
+  ad=0 pd=0 as=0 ps=0
M1109 DFFNEGX1_84/a_17_6# OAI21X1_126/Y gnd Gnd nfet w=10 l=2
+  ad=0 pd=0 as=0 ps=0
M1110 vdd invader_1_coord_x[3] HAX1_9/a_2_74# vdd pfet w=20 l=2
+  ad=59.999996p pd=26u as=100p ps=50u
M1111 HAX1_9/a_41_74# HAX1_9/a_2_74# vdd vdd pfet w=20 l=2
+  ad=0.11n pd=46u as=59.999996p ps=26u
M1112 HAX1_9/a_9_6# invader_1_coord_x[3] gnd Gnd nfet w=20 l=2
+  ad=29.999998p pd=23u as=100p ps=50u
M1113 HAX1_9/a_41_74# HAX1_9/B HAX1_9/a_38_6# Gnd nfet w=20 l=2
+  ad=59.999996p pd=26u as=59.999996p ps=26u
M1114 vdd invader_1_coord_x[3] HAX1_9/a_49_54# vdd pfet w=40 l=2
+  ad=0.2n pd=90u as=59.999996p ps=43u
M1115 vdd HAX1_9/a_2_74# OR2X1_2/B vdd pfet w=20 l=2
+  ad=59.999996p pd=26u as=100p ps=50u
M1116 HAX1_9/a_38_6# HAX1_9/a_2_74# gnd Gnd nfet w=20 l=2
+  ad=59.999996p pd=26u as=54p ps=26u
M1117 HAX1_9/YS HAX1_9/a_41_74# vdd vdd pfet w=20 l=2
+  ad=100p pd=50u as=100p ps=50u
M1118 HAX1_9/a_38_6# invader_1_coord_x[3] HAX1_9/a_41_74# Gnd nfet w=20 l=2
+  ad=96p pd=50u as=59.999996p ps=26u
M1119 HAX1_9/YS HAX1_9/a_41_74# gnd Gnd nfet w=10 l=2
+  ad=50p pd=30u as=50p ps=30u
M1120 HAX1_9/a_2_74# HAX1_9/B vdd vdd pfet w=20 l=2
+  ad=100p pd=50u as=59.999996p ps=26u
M1121 HAX1_9/a_2_74# HAX1_9/B HAX1_9/a_9_6# Gnd nfet w=20 l=2
+  ad=100p pd=50u as=29.999998p ps=23u
M1122 HAX1_9/a_49_54# HAX1_9/B HAX1_9/a_41_74# vdd pfet w=40 l=2
+  ad=59.999996p pd=43u as=0.11n ps=46u
M1123 gnd HAX1_9/a_2_74# OR2X1_2/B Gnd nfet w=10 l=2
+  ad=54p pd=26u as=50p ps=30u
M1124 AND2X2_5/a_2_6# invader_1_coord_x[1] vdd vdd pfet w=20 l=2
+  ad=59.999996p pd=26u as=100p ps=50u
M1125 AND2X2_5/a_9_6# invader_1_coord_x[1] AND2X2_5/a_2_6# Gnd nfet w=20 l=2
+  ad=29.999998p pd=23u as=100p ps=50u
M1126 XOR2X1_5/A AND2X2_5/a_2_6# gnd Gnd nfet w=20 l=2
+  ad=100p pd=50u as=59.999996p ps=26u
M1127 XOR2X1_5/A AND2X2_5/a_2_6# vdd vdd pfet w=40 l=2
+  ad=0.2n pd=90u as=0.108n ps=46u
M1128 vdd invader_1_coord_x[2] AND2X2_5/a_2_6# vdd pfet w=20 l=2
+  ad=0.108n pd=46u as=59.999996p ps=26u
M1129 gnd invader_1_coord_x[2] AND2X2_5/a_9_6# Gnd nfet w=20 l=2
+  ad=59.999996p pd=26u as=29.999998p ps=23u
M1130 gnd INVX2_49/Y AOI22X1_0/a_28_6# Gnd nfet w=20 l=2
+  ad=100p pd=50u as=29.999998p ps=23u
M1131 OR2X1_0/A INVX2_49/Y AOI22X1_0/a_11_6# Gnd nfet w=20 l=2
+  ad=100p pd=30u as=29.999998p ps=23u
M1132 AOI22X1_0/a_11_6# AOI22X1_0/A gnd Gnd nfet w=20 l=2
+  ad=29.999998p pd=23u as=100p ps=50u
M1133 AOI22X1_0/a_2_54# INVX2_49/Y vdd vdd pfet w=40 l=2
+  ad=0.12n pd=46u as=0.12n ps=46u
M1134 AOI22X1_0/a_28_6# OAI21X1_1/Y OR2X1_0/A Gnd nfet w=20 l=2
+  ad=29.999998p pd=23u as=100p ps=30u
M1135 vdd AOI22X1_0/A AOI22X1_0/a_2_54# vdd pfet w=40 l=2
+  ad=0.12n pd=46u as=0.2n ps=90u
M1136 OR2X1_0/A OAI21X1_1/Y AOI22X1_0/a_2_54# vdd pfet w=40 l=2
+  ad=0.12n pd=46u as=0.12n ps=46u
M1137 AOI22X1_0/a_2_54# INVX2_49/Y OR2X1_0/A vdd pfet w=40 l=2
+  ad=0.2n pd=90u as=0.12n ps=46u
M1138 OAI21X1_48/C INVX2_15/Y vdd vdd pfet w=20 l=2
+  ad=59.999996p pd=26u as=100p ps=50u
M1139 NAND2X1_10/a_9_6# INVX2_15/Y gnd Gnd nfet w=20 l=2
+  ad=29.999998p pd=23u as=100p ps=50u
M1140 vdd NOR2X1_24/Y OAI21X1_48/C vdd pfet w=20 l=2
+  ad=100p pd=50u as=59.999996p ps=26u
M1141 OAI21X1_48/C NOR2X1_24/Y NAND2X1_10/a_9_6# Gnd nfet w=20 l=2
+  ad=100p pd=50u as=29.999998p ps=23u
M1142 OAI21X1_49/B INVX2_16/A vdd vdd pfet w=20 l=2
+  ad=0.12n pd=52u as=0 ps=0
M1143 NAND2X1_32/a_9_6# INVX2_16/A gnd Gnd nfet w=20 l=2
+  ad=59.999996p pd=46u as=0 ps=0
M1144 vdd INVX2_22/Y OAI21X1_49/B vdd pfet w=20 l=2
+  ad=0 pd=0 as=0 ps=0
M1145 OAI21X1_49/B INVX2_22/Y NAND2X1_32/a_9_6# Gnd nfet w=20 l=2
+  ad=100p pd=50u as=0 ps=0
M1146 NAND3X1_7/A player_bullet_coord_y[3] vdd vdd pfet w=20 l=2
+  ad=0.12n pd=52u as=0 ps=0
M1147 NAND2X1_21/a_9_6# player_bullet_coord_y[3] gnd Gnd nfet w=20 l=2
+  ad=59.999996p pd=46u as=0 ps=0
M1148 vdd INVX2_77/Y NAND3X1_7/A vdd pfet w=20 l=2
+  ad=0 pd=0 as=0 ps=0
M1149 NAND3X1_7/A INVX2_77/Y NAND2X1_21/a_9_6# Gnd nfet w=20 l=2
+  ad=100p pd=50u as=0 ps=0
M1150 OAI21X1_74/A NOR2X1_35/B vdd vdd pfet w=20 l=2
+  ad=0.12n pd=52u as=0 ps=0
M1151 NAND2X1_43/a_9_6# NOR2X1_35/B gnd Gnd nfet w=20 l=2
+  ad=59.999996p pd=46u as=0 ps=0
M1152 vdd INVX2_56/Y OAI21X1_74/A vdd pfet w=20 l=2
+  ad=0 pd=0 as=0 ps=0
M1153 OAI21X1_74/A INVX2_56/Y NAND2X1_43/a_9_6# Gnd nfet w=20 l=2
+  ad=100p pd=50u as=0 ps=0
M1154 NAND2X1_54/Y INVX2_176/Y vdd vdd pfet w=20 l=2
+  ad=0.12n pd=52u as=0 ps=0
M1155 NAND2X1_54/a_9_6# INVX2_176/Y gnd Gnd nfet w=20 l=2
+  ad=59.999996p pd=46u as=0 ps=0
M1156 vdd NOR2X1_45/Y NAND2X1_54/Y vdd pfet w=20 l=2
+  ad=0 pd=0 as=0 ps=0
M1157 NAND2X1_54/Y NOR2X1_45/Y NAND2X1_54/a_9_6# Gnd nfet w=20 l=2
+  ad=100p pd=50u as=0 ps=0
M1158 NAND2X1_65/Y INVX2_99/A vdd vdd pfet w=20 l=2
+  ad=0.12n pd=52u as=0 ps=0
M1159 NAND2X1_65/a_9_6# INVX2_99/A gnd Gnd nfet w=20 l=2
+  ad=59.999996p pd=46u as=0 ps=0
M1160 vdd INVX2_101/A NAND2X1_65/Y vdd pfet w=20 l=2
+  ad=0 pd=0 as=0 ps=0
M1161 NAND2X1_65/Y INVX2_101/A NAND2X1_65/a_9_6# Gnd nfet w=20 l=2
+  ad=100p pd=50u as=0 ps=0
M1162 INVX2_113/A NAND2X1_76/A vdd vdd pfet w=20 l=2
+  ad=0.12n pd=52u as=0 ps=0
M1163 NAND2X1_76/a_9_6# NAND2X1_76/A gnd Gnd nfet w=20 l=2
+  ad=59.999996p pd=46u as=0 ps=0
M1164 vdd invader_1_display INVX2_113/A vdd pfet w=20 l=2
+  ad=0 pd=0 as=0 ps=0
M1165 INVX2_113/A invader_1_display NAND2X1_76/a_9_6# Gnd nfet w=20 l=2
+  ad=100p pd=50u as=0 ps=0
M1166 gnd player_coord_x[2] AOI22X1_41/a_28_6# Gnd nfet w=20 l=2
+  ad=0 pd=0 as=59.999996p ps=46u
M1167 AOI22X1_41/Y INVX2_175/Y AOI22X1_41/a_11_6# Gnd nfet w=20 l=2
+  ad=0.2n pd=60u as=59.999996p ps=46u
M1168 AOI22X1_41/a_11_6# INVX2_163/Y gnd Gnd nfet w=20 l=2
+  ad=0 pd=0 as=0 ps=0
M1169 AOI22X1_41/a_2_54# INVX2_175/Y vdd vdd pfet w=40 l=2
+  ad=0.64n pd=0.272m as=0 ps=0
M1170 AOI22X1_41/a_28_6# INVX2_162/A AOI22X1_41/Y Gnd nfet w=20 l=2
+  ad=0 pd=0 as=0 ps=0
M1171 vdd INVX2_163/Y AOI22X1_41/a_2_54# vdd pfet w=40 l=2
+  ad=0 pd=0 as=0 ps=0
M1172 AOI22X1_41/Y INVX2_162/A AOI22X1_41/a_2_54# vdd pfet w=40 l=2
+  ad=0.24n pd=92u as=0 ps=0
M1173 AOI22X1_41/a_2_54# player_coord_x[2] AOI22X1_41/Y vdd pfet w=40 l=2
+  ad=0 pd=0 as=0 ps=0
M1174 gnd INVX2_25/Y AOI22X1_30/a_28_6# Gnd nfet w=20 l=2
+  ad=0 pd=0 as=59.999996p ps=46u
M1175 INVX2_157/A AND2X2_8/A AOI22X1_30/a_11_6# Gnd nfet w=20 l=2
+  ad=0.2n pd=60u as=59.999996p ps=46u
M1176 AOI22X1_30/a_11_6# INVX2_25/Y gnd Gnd nfet w=20 l=2
+  ad=0 pd=0 as=0 ps=0
M1177 AOI22X1_30/a_2_54# AND2X2_8/A vdd vdd pfet w=40 l=2
+  ad=0.64n pd=0.272m as=0 ps=0
M1178 AOI22X1_30/a_28_6# AND2X2_9/B INVX2_157/A Gnd nfet w=20 l=2
+  ad=0 pd=0 as=0 ps=0
M1179 vdd INVX2_25/Y AOI22X1_30/a_2_54# vdd pfet w=40 l=2
+  ad=0 pd=0 as=0 ps=0
M1180 INVX2_157/A AND2X2_9/B AOI22X1_30/a_2_54# vdd pfet w=40 l=2
+  ad=0.24n pd=92u as=0 ps=0
M1181 AOI22X1_30/a_2_54# INVX2_25/Y INVX2_157/A vdd pfet w=40 l=2
+  ad=0 pd=0 as=0 ps=0
M1182 gnd invader_1_coord_x[3] AOI22X1_52/a_28_6# Gnd nfet w=20 l=2
+  ad=0 pd=0 as=59.999996p ps=46u
M1183 INVX2_115/A invader_2_coord_x[3] AOI22X1_52/a_11_6# Gnd nfet w=20 l=2
+  ad=0.2n pd=60u as=59.999996p ps=46u
M1184 AOI22X1_52/a_11_6# OAI22X1_8/D gnd Gnd nfet w=20 l=2
+  ad=0 pd=0 as=0 ps=0
M1185 AOI22X1_52/a_2_54# invader_2_coord_x[3] vdd vdd pfet w=40 l=2
+  ad=0.64n pd=0.272m as=0 ps=0
M1186 AOI22X1_52/a_28_6# OAI22X1_8/A INVX2_115/A Gnd nfet w=20 l=2
+  ad=0 pd=0 as=0 ps=0
M1187 vdd OAI22X1_8/D AOI22X1_52/a_2_54# vdd pfet w=40 l=2
+  ad=0 pd=0 as=0 ps=0
M1188 INVX2_115/A OAI22X1_8/A AOI22X1_52/a_2_54# vdd pfet w=40 l=2
+  ad=0.24n pd=92u as=0 ps=0
M1189 AOI22X1_52/a_2_54# invader_1_coord_x[3] INVX2_115/A vdd pfet w=40 l=2
+  ad=0 pd=0 as=0 ps=0
M1190 gnd invader_1_coord_x[2] AOI22X1_63/a_28_6# Gnd nfet w=20 l=2
+  ad=0 pd=0 as=59.999996p ps=46u
M1191 NOR2X1_57/A NAND2X1_79/Y AOI22X1_63/a_11_6# Gnd nfet w=20 l=2
+  ad=0.2n pd=60u as=59.999996p ps=46u
M1192 AOI22X1_63/a_11_6# XNOR2X1_8/A gnd Gnd nfet w=20 l=2
+  ad=0 pd=0 as=0 ps=0
M1193 AOI22X1_63/a_2_54# NAND2X1_79/Y vdd vdd pfet w=40 l=2
+  ad=0.64n pd=0.272m as=0 ps=0
M1194 AOI22X1_63/a_28_6# INVX2_175/Y NOR2X1_57/A Gnd nfet w=20 l=2
+  ad=0 pd=0 as=0 ps=0
M1195 vdd XNOR2X1_8/A AOI22X1_63/a_2_54# vdd pfet w=40 l=2
+  ad=0 pd=0 as=0 ps=0
M1196 NOR2X1_57/A INVX2_175/Y AOI22X1_63/a_2_54# vdd pfet w=40 l=2
+  ad=0.24n pd=92u as=0 ps=0
M1197 AOI22X1_63/a_2_54# invader_1_coord_x[2] NOR2X1_57/A vdd pfet w=40 l=2
+  ad=0 pd=0 as=0 ps=0
M1198 gnd player_bullet_coord_y[1] OAI22X1_3/a_2_6# Gnd nfet w=20 l=2
+  ad=59.999996p pd=26u as=100p ps=50u
M1199 OAI22X1_3/a_2_6# player_bullet_coord_y[0] OAI22X1_3/Y Gnd nfet w=20 l=2
+  ad=100p pd=50u as=59.999996p ps=26u
M1200 OAI22X1_3/Y invader_1_coord_y[0] OAI22X1_3/a_2_6# Gnd nfet w=20 l=2
+  ad=59.999996p pd=26u as=59.999996p ps=26u
M1201 OAI22X1_3/Y INVX2_73/A OAI22X1_3/a_9_54# vdd pfet w=40 l=2
+  ad=0.24n pd=52u as=59.999996p ps=43u
M1202 OAI22X1_3/a_28_54# invader_1_coord_y[0] OAI22X1_3/Y vdd pfet w=40 l=2
+  ad=59.999996p pd=43u as=0.24n ps=52u
M1203 OAI22X1_3/a_9_54# player_bullet_coord_y[1] vdd vdd pfet w=40 l=2
+  ad=59.999996p pd=43u as=0.2n ps=90u
M1204 OAI22X1_3/a_2_6# INVX2_73/A gnd Gnd nfet w=20 l=2
+  ad=59.999996p pd=26u as=59.999996p ps=26u
M1205 vdd player_bullet_coord_y[0] OAI22X1_3/a_28_54# vdd pfet w=40 l=2
+  ad=0.2n pd=90u as=59.999996p ps=43u
M1206 INVX2_12/Y invader_bullet_coord_y[2] gnd Gnd nfet w=20 l=2
+  ad=100p pd=50u as=100p ps=50u
M1207 INVX2_12/Y invader_bullet_coord_y[2] vdd vdd pfet w=40 l=2
+  ad=0.2n pd=90u as=0.2n ps=90u
M1208 INVX2_23/Y player_bullet_coord_y[3] gnd Gnd nfet w=20 l=2
+  ad=100p pd=50u as=0 ps=0
M1209 INVX2_23/Y player_bullet_coord_y[3] vdd vdd pfet w=40 l=2
+  ad=0.2n pd=90u as=0 ps=0
M1210 INVX2_34/Y INVX2_34/A gnd Gnd nfet w=20 l=2
+  ad=100p pd=50u as=0 ps=0
M1211 INVX2_34/Y INVX2_34/A vdd vdd pfet w=40 l=2
+  ad=0.2n pd=90u as=0 ps=0
M1212 INVX2_45/Y INVX2_45/A gnd Gnd nfet w=20 l=2
+  ad=100p pd=50u as=0 ps=0
M1213 INVX2_45/Y INVX2_45/A vdd vdd pfet w=40 l=2
+  ad=0.2n pd=90u as=0 ps=0
M1214 INVX2_78/Y INVX2_78/A gnd Gnd nfet w=20 l=2
+  ad=100p pd=50u as=0 ps=0
M1215 INVX2_78/Y INVX2_78/A vdd vdd pfet w=40 l=2
+  ad=0.2n pd=90u as=0 ps=0
M1216 INVX2_67/Y INVX2_67/A gnd Gnd nfet w=20 l=2
+  ad=100p pd=50u as=0 ps=0
M1217 INVX2_67/Y INVX2_67/A vdd vdd pfet w=40 l=2
+  ad=0.2n pd=90u as=0 ps=0
M1218 INVX2_56/Y INVX2_56/A gnd Gnd nfet w=20 l=2
+  ad=100p pd=50u as=0 ps=0
M1219 INVX2_56/Y INVX2_56/A vdd vdd pfet w=40 l=2
+  ad=0.2n pd=90u as=0 ps=0
M1220 INVX2_89/Y INVX2_89/A gnd Gnd nfet w=20 l=2
+  ad=100p pd=50u as=0 ps=0
M1221 INVX2_89/Y INVX2_89/A vdd vdd pfet w=40 l=2
+  ad=0.2n pd=90u as=0 ps=0
M1222 gnd player_bullet_coord_x[2] OAI21X1_19/a_2_6# Gnd nfet w=20 l=2
+  ad=59.999996p pd=26u as=100p ps=50u
M1223 vdd NAND3X1_6/A OAI21X1_19/Y vdd pfet w=20 l=2
+  ad=100p pd=50u as=0.11n ps=46u
M1224 OAI21X1_19/Y NAND3X1_6/A OAI21X1_19/a_2_6# Gnd nfet w=20 l=2
+  ad=100p pd=50u as=59.999996p ps=26u
M1225 OAI21X1_19/Y INVX2_65/Y OAI21X1_19/a_9_54# vdd pfet w=40 l=2
+  ad=0.11n pd=46u as=59.999996p ps=43u
M1226 OAI21X1_19/a_9_54# player_bullet_coord_x[2] vdd vdd pfet w=40 l=2
+  ad=59.999996p pd=43u as=0.2n ps=90u
M1227 OAI21X1_19/a_2_6# INVX2_65/Y gnd Gnd nfet w=20 l=2
+  ad=59.999996p pd=26u as=59.999996p ps=26u
M1228 gnd XNOR2X1_6/A XNOR2X1_6/a_2_6# Gnd nfet w=20 l=2
+  ad=70p pd=27u as=100p ps=50u
M1229 XNOR2X1_6/Y XNOR2X1_6/A XNOR2X1_6/a_18_6# Gnd nfet w=20 l=2
+  ad=100p pd=30u as=29.999998p ps=23u
M1230 XNOR2X1_6/a_12_41# XNOR2X1_6/B gnd Gnd nfet w=20 l=2
+  ad=100p pd=50u as=70p ps=27u
M1231 XNOR2X1_6/a_18_54# XNOR2X1_6/a_12_41# vdd vdd pfet w=40 l=2
+  ad=59.999996p pd=43u as=0.14n ps=47u
M1232 XNOR2X1_6/a_35_6# XNOR2X1_6/a_2_6# XNOR2X1_6/Y Gnd nfet w=20 l=2
+  ad=29.999998p pd=23u as=100p ps=30u
M1233 XNOR2X1_6/a_18_6# XNOR2X1_6/a_12_41# gnd Gnd nfet w=20 l=2
+  ad=29.999998p pd=23u as=70p ps=27u
M1234 vdd XNOR2X1_6/A XNOR2X1_6/a_2_6# vdd pfet w=40 l=2
+  ad=0.14n pd=47u as=0.2n ps=90u
M1235 vdd XNOR2X1_6/B XNOR2X1_6/a_35_54# vdd pfet w=40 l=2
+  ad=0.14n pd=47u as=59.999996p ps=43u
M1236 XNOR2X1_6/Y XNOR2X1_6/a_2_6# XNOR2X1_6/a_18_54# vdd pfet w=40 l=2
+  ad=0.2n pd=50u as=59.999996p ps=43u
M1237 XNOR2X1_6/a_35_54# XNOR2X1_6/A XNOR2X1_6/Y vdd pfet w=40 l=2
+  ad=59.999996p pd=43u as=0.2n ps=50u
M1238 XNOR2X1_6/a_12_41# XNOR2X1_6/B vdd vdd pfet w=40 l=2
+  ad=0.2n pd=90u as=0.14n ps=47u
M1239 gnd XNOR2X1_6/B XNOR2X1_6/a_35_6# Gnd nfet w=20 l=2
+  ad=70p pd=27u as=29.999998p ps=23u
M1240 DFFNEGX1_30/a_76_6# BUFX2_5/Y DFFNEGX1_30/a_66_6# Gnd nfet w=10 l=2
+  ad=29.999998p pd=26u as=80p ps=36u
M1241 gnd BUFX2_5/Y DFFNEGX1_30/a_2_6# Gnd nfet w=20 l=2
+  ad=0 pd=0 as=100p ps=50u
M1242 DFFNEGX1_30/a_66_6# DFFNEGX1_30/a_2_6# DFFNEGX1_30/a_61_6# Gnd nfet w=10 l=2
+  ad=0 pd=0 as=29.999998p ps=26u
M1243 invader_2_display DFFNEGX1_30/a_66_6# gnd Gnd nfet w=20 l=2
+  ad=100p pd=50u as=0 ps=0
M1244 DFFNEGX1_30/a_23_6# BUFX2_5/Y DFFNEGX1_30/a_17_6# Gnd nfet w=10 l=2
+  ad=59.999996p pd=32u as=40p ps=28u
M1245 DFFNEGX1_30/a_23_6# DFFNEGX1_30/a_2_6# DFFNEGX1_30/a_17_74# vdd pfet w=20 l=2
+  ad=0.12n pd=52u as=80p ps=48u
M1246 gnd DFFNEGX1_30/a_34_4# DFFNEGX1_30/a_31_6# Gnd nfet w=10 l=2
+  ad=0 pd=0 as=29.999998p ps=26u
M1247 vdd DFFNEGX1_30/a_34_4# DFFNEGX1_30/a_31_74# vdd pfet w=20 l=2
+  ad=0 pd=0 as=80p ps=48u
M1248 DFFNEGX1_30/a_61_74# DFFNEGX1_30/a_34_4# vdd vdd pfet w=20 l=2
+  ad=59.999996p pd=46u as=0 ps=0
M1249 DFFNEGX1_30/a_34_4# DFFNEGX1_30/a_23_6# vdd vdd pfet w=20 l=2
+  ad=100p pd=50u as=0 ps=0
M1250 DFFNEGX1_30/a_34_4# DFFNEGX1_30/a_23_6# gnd Gnd nfet w=10 l=2
+  ad=50p pd=30u as=0 ps=0
M1251 vdd invader_2_display DFFNEGX1_30/a_76_84# vdd pfet w=10 l=2
+  ad=0 pd=0 as=29.999998p ps=26u
M1252 gnd invader_2_display DFFNEGX1_30/a_76_6# Gnd nfet w=10 l=2
+  ad=0 pd=0 as=0 ps=0
M1253 DFFNEGX1_30/a_61_6# DFFNEGX1_30/a_34_4# gnd Gnd nfet w=10 l=2
+  ad=0 pd=0 as=0 ps=0
M1254 DFFNEGX1_30/a_76_84# DFFNEGX1_30/a_2_6# DFFNEGX1_30/a_66_6# vdd pfet w=10 l=2
+  ad=0 pd=0 as=0.15n ps=56u
M1255 invader_2_display DFFNEGX1_30/a_66_6# vdd vdd pfet w=40 l=2
+  ad=0.2n pd=90u as=0 ps=0
M1256 vdd BUFX2_5/Y DFFNEGX1_30/a_2_6# vdd pfet w=40 l=2
+  ad=0 pd=0 as=0.2n ps=90u
M1257 DFFNEGX1_30/a_31_6# DFFNEGX1_30/a_2_6# DFFNEGX1_30/a_23_6# Gnd nfet w=10 l=2
+  ad=0 pd=0 as=0 ps=0
M1258 DFFNEGX1_30/a_66_6# BUFX2_5/Y DFFNEGX1_30/a_61_74# vdd pfet w=20 l=2
+  ad=0 pd=0 as=0 ps=0
M1259 DFFNEGX1_30/a_17_74# OAI21X1_65/Y vdd vdd pfet w=20 l=2
+  ad=0 pd=0 as=0 ps=0
M1260 DFFNEGX1_30/a_31_74# BUFX2_5/Y DFFNEGX1_30/a_23_6# vdd pfet w=20 l=2
+  ad=0 pd=0 as=0 ps=0
M1261 DFFNEGX1_30/a_17_6# OAI21X1_65/Y gnd Gnd nfet w=10 l=2
+  ad=0 pd=0 as=0 ps=0
M1262 DFFNEGX1_41/a_76_6# BUFX2_5/Y DFFNEGX1_41/a_66_6# Gnd nfet w=10 l=2
+  ad=29.999998p pd=26u as=80p ps=36u
M1263 gnd BUFX2_5/Y DFFNEGX1_41/a_2_6# Gnd nfet w=20 l=2
+  ad=0 pd=0 as=100p ps=50u
M1264 DFFNEGX1_41/a_66_6# DFFNEGX1_41/a_2_6# DFFNEGX1_41/a_61_6# Gnd nfet w=10 l=2
+  ad=0 pd=0 as=29.999998p ps=26u
M1265 INVX2_57/A DFFNEGX1_41/a_66_6# gnd Gnd nfet w=20 l=2
+  ad=100p pd=50u as=0 ps=0
M1266 DFFNEGX1_41/a_23_6# BUFX2_5/Y DFFNEGX1_41/a_17_6# Gnd nfet w=10 l=2
+  ad=59.999996p pd=32u as=40p ps=28u
M1267 DFFNEGX1_41/a_23_6# DFFNEGX1_41/a_2_6# DFFNEGX1_41/a_17_74# vdd pfet w=20 l=2
+  ad=0.12n pd=52u as=80p ps=48u
M1268 gnd DFFNEGX1_41/a_34_4# DFFNEGX1_41/a_31_6# Gnd nfet w=10 l=2
+  ad=0 pd=0 as=29.999998p ps=26u
M1269 vdd DFFNEGX1_41/a_34_4# DFFNEGX1_41/a_31_74# vdd pfet w=20 l=2
+  ad=0 pd=0 as=80p ps=48u
M1270 DFFNEGX1_41/a_61_74# DFFNEGX1_41/a_34_4# vdd vdd pfet w=20 l=2
+  ad=59.999996p pd=46u as=0 ps=0
M1271 DFFNEGX1_41/a_34_4# DFFNEGX1_41/a_23_6# vdd vdd pfet w=20 l=2
+  ad=100p pd=50u as=0 ps=0
M1272 DFFNEGX1_41/a_34_4# DFFNEGX1_41/a_23_6# gnd Gnd nfet w=10 l=2
+  ad=50p pd=30u as=0 ps=0
M1273 vdd INVX2_57/A DFFNEGX1_41/a_76_84# vdd pfet w=10 l=2
+  ad=0 pd=0 as=29.999998p ps=26u
M1274 gnd INVX2_57/A DFFNEGX1_41/a_76_6# Gnd nfet w=10 l=2
+  ad=0 pd=0 as=0 ps=0
M1275 DFFNEGX1_41/a_61_6# DFFNEGX1_41/a_34_4# gnd Gnd nfet w=10 l=2
+  ad=0 pd=0 as=0 ps=0
M1276 DFFNEGX1_41/a_76_84# DFFNEGX1_41/a_2_6# DFFNEGX1_41/a_66_6# vdd pfet w=10 l=2
+  ad=0 pd=0 as=0.15n ps=56u
M1277 INVX2_57/A DFFNEGX1_41/a_66_6# vdd vdd pfet w=40 l=2
+  ad=0.2n pd=90u as=0 ps=0
M1278 vdd BUFX2_5/Y DFFNEGX1_41/a_2_6# vdd pfet w=40 l=2
+  ad=0 pd=0 as=0.2n ps=90u
M1279 DFFNEGX1_41/a_31_6# DFFNEGX1_41/a_2_6# DFFNEGX1_41/a_23_6# Gnd nfet w=10 l=2
+  ad=0 pd=0 as=0 ps=0
M1280 DFFNEGX1_41/a_66_6# BUFX2_5/Y DFFNEGX1_41/a_61_74# vdd pfet w=20 l=2
+  ad=0 pd=0 as=0 ps=0
M1281 DFFNEGX1_41/a_17_74# OAI21X1_75/Y vdd vdd pfet w=20 l=2
+  ad=0 pd=0 as=0 ps=0
M1282 DFFNEGX1_41/a_31_74# BUFX2_5/Y DFFNEGX1_41/a_23_6# vdd pfet w=20 l=2
+  ad=0 pd=0 as=0 ps=0
M1283 DFFNEGX1_41/a_17_6# OAI21X1_75/Y gnd Gnd nfet w=10 l=2
+  ad=0 pd=0 as=0 ps=0
M1284 DFFNEGX1_52/a_76_6# BUFX2_4/Y DFFNEGX1_52/a_66_6# Gnd nfet w=10 l=2
+  ad=29.999998p pd=26u as=80p ps=36u
M1285 gnd BUFX2_4/Y DFFNEGX1_52/a_2_6# Gnd nfet w=20 l=2
+  ad=0 pd=0 as=100p ps=50u
M1286 DFFNEGX1_52/a_66_6# DFFNEGX1_52/a_2_6# DFFNEGX1_52/a_61_6# Gnd nfet w=10 l=2
+  ad=0 pd=0 as=29.999998p ps=26u
M1287 OR2X1_20/A DFFNEGX1_52/a_66_6# gnd Gnd nfet w=20 l=2
+  ad=100p pd=50u as=0 ps=0
M1288 DFFNEGX1_52/a_23_6# BUFX2_4/Y DFFNEGX1_52/a_17_6# Gnd nfet w=10 l=2
+  ad=59.999996p pd=32u as=40p ps=28u
M1289 DFFNEGX1_52/a_23_6# DFFNEGX1_52/a_2_6# DFFNEGX1_52/a_17_74# vdd pfet w=20 l=2
+  ad=0.12n pd=52u as=80p ps=48u
M1290 gnd DFFNEGX1_52/a_34_4# DFFNEGX1_52/a_31_6# Gnd nfet w=10 l=2
+  ad=0 pd=0 as=29.999998p ps=26u
M1291 vdd DFFNEGX1_52/a_34_4# DFFNEGX1_52/a_31_74# vdd pfet w=20 l=2
+  ad=0 pd=0 as=80p ps=48u
M1292 DFFNEGX1_52/a_61_74# DFFNEGX1_52/a_34_4# vdd vdd pfet w=20 l=2
+  ad=59.999996p pd=46u as=0 ps=0
M1293 DFFNEGX1_52/a_34_4# DFFNEGX1_52/a_23_6# vdd vdd pfet w=20 l=2
+  ad=100p pd=50u as=0 ps=0
M1294 DFFNEGX1_52/a_34_4# DFFNEGX1_52/a_23_6# gnd Gnd nfet w=10 l=2
+  ad=50p pd=30u as=0 ps=0
M1295 vdd OR2X1_20/A DFFNEGX1_52/a_76_84# vdd pfet w=10 l=2
+  ad=0 pd=0 as=29.999998p ps=26u
M1296 gnd OR2X1_20/A DFFNEGX1_52/a_76_6# Gnd nfet w=10 l=2
+  ad=0 pd=0 as=0 ps=0
M1297 DFFNEGX1_52/a_61_6# DFFNEGX1_52/a_34_4# gnd Gnd nfet w=10 l=2
+  ad=0 pd=0 as=0 ps=0
M1298 DFFNEGX1_52/a_76_84# DFFNEGX1_52/a_2_6# DFFNEGX1_52/a_66_6# vdd pfet w=10 l=2
+  ad=0 pd=0 as=0.15n ps=56u
M1299 OR2X1_20/A DFFNEGX1_52/a_66_6# vdd vdd pfet w=40 l=2
+  ad=0.2n pd=90u as=0 ps=0
M1300 vdd BUFX2_4/Y DFFNEGX1_52/a_2_6# vdd pfet w=40 l=2
+  ad=0 pd=0 as=0.2n ps=90u
M1301 DFFNEGX1_52/a_31_6# DFFNEGX1_52/a_2_6# DFFNEGX1_52/a_23_6# Gnd nfet w=10 l=2
+  ad=0 pd=0 as=0 ps=0
M1302 DFFNEGX1_52/a_66_6# BUFX2_4/Y DFFNEGX1_52/a_61_74# vdd pfet w=20 l=2
+  ad=0 pd=0 as=0 ps=0
M1303 DFFNEGX1_52/a_17_74# OAI21X1_74/Y vdd vdd pfet w=20 l=2
+  ad=0 pd=0 as=0 ps=0
M1304 DFFNEGX1_52/a_31_74# BUFX2_4/Y DFFNEGX1_52/a_23_6# vdd pfet w=20 l=2
+  ad=0 pd=0 as=0 ps=0
M1305 DFFNEGX1_52/a_17_6# OAI21X1_74/Y gnd Gnd nfet w=10 l=2
+  ad=0 pd=0 as=0 ps=0
M1306 DFFNEGX1_63/a_76_6# BUFX2_3/Y DFFNEGX1_63/a_66_6# Gnd nfet w=10 l=2
+  ad=29.999998p pd=26u as=80p ps=36u
M1307 gnd BUFX2_3/Y DFFNEGX1_63/a_2_6# Gnd nfet w=20 l=2
+  ad=0 pd=0 as=100p ps=50u
M1308 DFFNEGX1_63/a_66_6# DFFNEGX1_63/a_2_6# DFFNEGX1_63/a_61_6# Gnd nfet w=10 l=2
+  ad=0 pd=0 as=29.999998p ps=26u
M1309 shield_coord_x[1] DFFNEGX1_63/a_66_6# gnd Gnd nfet w=20 l=2
+  ad=100p pd=50u as=0 ps=0
M1310 DFFNEGX1_63/a_23_6# BUFX2_3/Y DFFNEGX1_63/a_17_6# Gnd nfet w=10 l=2
+  ad=59.999996p pd=32u as=40p ps=28u
M1311 DFFNEGX1_63/a_23_6# DFFNEGX1_63/a_2_6# DFFNEGX1_63/a_17_74# vdd pfet w=20 l=2
+  ad=0.12n pd=52u as=80p ps=48u
M1312 gnd DFFNEGX1_63/a_34_4# DFFNEGX1_63/a_31_6# Gnd nfet w=10 l=2
+  ad=0 pd=0 as=29.999998p ps=26u
M1313 vdd DFFNEGX1_63/a_34_4# DFFNEGX1_63/a_31_74# vdd pfet w=20 l=2
+  ad=0 pd=0 as=80p ps=48u
M1314 DFFNEGX1_63/a_61_74# DFFNEGX1_63/a_34_4# vdd vdd pfet w=20 l=2
+  ad=59.999996p pd=46u as=0 ps=0
M1315 DFFNEGX1_63/a_34_4# DFFNEGX1_63/a_23_6# vdd vdd pfet w=20 l=2
+  ad=100p pd=50u as=0 ps=0
M1316 DFFNEGX1_63/a_34_4# DFFNEGX1_63/a_23_6# gnd Gnd nfet w=10 l=2
+  ad=50p pd=30u as=0 ps=0
M1317 vdd shield_coord_x[1] DFFNEGX1_63/a_76_84# vdd pfet w=10 l=2
+  ad=0 pd=0 as=29.999998p ps=26u
M1318 gnd shield_coord_x[1] DFFNEGX1_63/a_76_6# Gnd nfet w=10 l=2
+  ad=0 pd=0 as=0 ps=0
M1319 DFFNEGX1_63/a_61_6# DFFNEGX1_63/a_34_4# gnd Gnd nfet w=10 l=2
+  ad=0 pd=0 as=0 ps=0
M1320 DFFNEGX1_63/a_76_84# DFFNEGX1_63/a_2_6# DFFNEGX1_63/a_66_6# vdd pfet w=10 l=2
+  ad=0 pd=0 as=0.15n ps=56u
M1321 shield_coord_x[1] DFFNEGX1_63/a_66_6# vdd vdd pfet w=40 l=2
+  ad=0.2n pd=90u as=0 ps=0
M1322 vdd BUFX2_3/Y DFFNEGX1_63/a_2_6# vdd pfet w=40 l=2
+  ad=0 pd=0 as=0.2n ps=90u
M1323 DFFNEGX1_63/a_31_6# DFFNEGX1_63/a_2_6# DFFNEGX1_63/a_23_6# Gnd nfet w=10 l=2
+  ad=0 pd=0 as=0 ps=0
M1324 DFFNEGX1_63/a_66_6# BUFX2_3/Y DFFNEGX1_63/a_61_74# vdd pfet w=20 l=2
+  ad=0 pd=0 as=0 ps=0
M1325 DFFNEGX1_63/a_17_74# OAI21X1_94/Y vdd vdd pfet w=20 l=2
+  ad=0 pd=0 as=0 ps=0
M1326 DFFNEGX1_63/a_31_74# BUFX2_3/Y DFFNEGX1_63/a_23_6# vdd pfet w=20 l=2
+  ad=0 pd=0 as=0 ps=0
M1327 DFFNEGX1_63/a_17_6# OAI21X1_94/Y gnd Gnd nfet w=10 l=2
+  ad=0 pd=0 as=0 ps=0
M1328 DFFNEGX1_74/a_76_6# BUFX2_3/Y DFFNEGX1_74/a_66_6# Gnd nfet w=10 l=2
+  ad=29.999998p pd=26u as=80p ps=36u
M1329 gnd BUFX2_3/Y DFFNEGX1_74/a_2_6# Gnd nfet w=20 l=2
+  ad=0 pd=0 as=100p ps=50u
M1330 DFFNEGX1_74/a_66_6# DFFNEGX1_74/a_2_6# DFFNEGX1_74/a_61_6# Gnd nfet w=10 l=2
+  ad=0 pd=0 as=29.999998p ps=26u
M1331 player_coord_x[1] DFFNEGX1_74/a_66_6# gnd Gnd nfet w=20 l=2
+  ad=100p pd=50u as=0 ps=0
M1332 DFFNEGX1_74/a_23_6# BUFX2_3/Y DFFNEGX1_74/a_17_6# Gnd nfet w=10 l=2
+  ad=59.999996p pd=32u as=40p ps=28u
M1333 DFFNEGX1_74/a_23_6# DFFNEGX1_74/a_2_6# DFFNEGX1_74/a_17_74# vdd pfet w=20 l=2
+  ad=0.12n pd=52u as=80p ps=48u
M1334 gnd DFFNEGX1_74/a_34_4# DFFNEGX1_74/a_31_6# Gnd nfet w=10 l=2
+  ad=0 pd=0 as=29.999998p ps=26u
M1335 vdd DFFNEGX1_74/a_34_4# DFFNEGX1_74/a_31_74# vdd pfet w=20 l=2
+  ad=0 pd=0 as=80p ps=48u
M1336 DFFNEGX1_74/a_61_74# DFFNEGX1_74/a_34_4# vdd vdd pfet w=20 l=2
+  ad=59.999996p pd=46u as=0 ps=0
M1337 DFFNEGX1_74/a_34_4# DFFNEGX1_74/a_23_6# vdd vdd pfet w=20 l=2
+  ad=100p pd=50u as=0 ps=0
M1338 DFFNEGX1_74/a_34_4# DFFNEGX1_74/a_23_6# gnd Gnd nfet w=10 l=2
+  ad=50p pd=30u as=0 ps=0
M1339 vdd player_coord_x[1] DFFNEGX1_74/a_76_84# vdd pfet w=10 l=2
+  ad=0 pd=0 as=29.999998p ps=26u
M1340 gnd player_coord_x[1] DFFNEGX1_74/a_76_6# Gnd nfet w=10 l=2
+  ad=0 pd=0 as=0 ps=0
M1341 DFFNEGX1_74/a_61_6# DFFNEGX1_74/a_34_4# gnd Gnd nfet w=10 l=2
+  ad=0 pd=0 as=0 ps=0
M1342 DFFNEGX1_74/a_76_84# DFFNEGX1_74/a_2_6# DFFNEGX1_74/a_66_6# vdd pfet w=10 l=2
+  ad=0 pd=0 as=0.15n ps=56u
M1343 player_coord_x[1] DFFNEGX1_74/a_66_6# vdd vdd pfet w=40 l=2
+  ad=0.2n pd=90u as=0 ps=0
M1344 vdd BUFX2_3/Y DFFNEGX1_74/a_2_6# vdd pfet w=40 l=2
+  ad=0 pd=0 as=0.2n ps=90u
M1345 DFFNEGX1_74/a_31_6# DFFNEGX1_74/a_2_6# DFFNEGX1_74/a_23_6# Gnd nfet w=10 l=2
+  ad=0 pd=0 as=0 ps=0
M1346 DFFNEGX1_74/a_66_6# BUFX2_3/Y DFFNEGX1_74/a_61_74# vdd pfet w=20 l=2
+  ad=0 pd=0 as=0 ps=0
M1347 DFFNEGX1_74/a_17_74# OR2X1_14/Y vdd vdd pfet w=20 l=2
+  ad=0 pd=0 as=0 ps=0
M1348 DFFNEGX1_74/a_31_74# BUFX2_3/Y DFFNEGX1_74/a_23_6# vdd pfet w=20 l=2
+  ad=0 pd=0 as=0 ps=0
M1349 DFFNEGX1_74/a_17_6# OR2X1_14/Y gnd Gnd nfet w=10 l=2
+  ad=0 pd=0 as=0 ps=0
M1350 DFFNEGX1_85/a_76_6# BUFX2_2/Y DFFNEGX1_85/a_66_6# Gnd nfet w=10 l=2
+  ad=29.999998p pd=26u as=80p ps=36u
M1351 gnd BUFX2_2/Y DFFNEGX1_85/a_2_6# Gnd nfet w=20 l=2
+  ad=0 pd=0 as=100p ps=50u
M1352 DFFNEGX1_85/a_66_6# DFFNEGX1_85/a_2_6# DFFNEGX1_85/a_61_6# Gnd nfet w=10 l=2
+  ad=0 pd=0 as=29.999998p ps=26u
M1353 AND2X2_8/A DFFNEGX1_85/a_66_6# gnd Gnd nfet w=20 l=2
+  ad=100p pd=50u as=0 ps=0
M1354 DFFNEGX1_85/a_23_6# BUFX2_2/Y DFFNEGX1_85/a_17_6# Gnd nfet w=10 l=2
+  ad=59.999996p pd=32u as=40p ps=28u
M1355 DFFNEGX1_85/a_23_6# DFFNEGX1_85/a_2_6# DFFNEGX1_85/a_17_74# vdd pfet w=20 l=2
+  ad=0.12n pd=52u as=80p ps=48u
M1356 gnd DFFNEGX1_85/a_34_4# DFFNEGX1_85/a_31_6# Gnd nfet w=10 l=2
+  ad=0 pd=0 as=29.999998p ps=26u
M1357 vdd DFFNEGX1_85/a_34_4# DFFNEGX1_85/a_31_74# vdd pfet w=20 l=2
+  ad=0 pd=0 as=80p ps=48u
M1358 DFFNEGX1_85/a_61_74# DFFNEGX1_85/a_34_4# vdd vdd pfet w=20 l=2
+  ad=59.999996p pd=46u as=0 ps=0
M1359 DFFNEGX1_85/a_34_4# DFFNEGX1_85/a_23_6# vdd vdd pfet w=20 l=2
+  ad=100p pd=50u as=0 ps=0
M1360 DFFNEGX1_85/a_34_4# DFFNEGX1_85/a_23_6# gnd Gnd nfet w=10 l=2
+  ad=50p pd=30u as=0 ps=0
M1361 vdd AND2X2_8/A DFFNEGX1_85/a_76_84# vdd pfet w=10 l=2
+  ad=0 pd=0 as=29.999998p ps=26u
M1362 gnd AND2X2_8/A DFFNEGX1_85/a_76_6# Gnd nfet w=10 l=2
+  ad=0 pd=0 as=0 ps=0
M1363 DFFNEGX1_85/a_61_6# DFFNEGX1_85/a_34_4# gnd Gnd nfet w=10 l=2
+  ad=0 pd=0 as=0 ps=0
M1364 DFFNEGX1_85/a_76_84# DFFNEGX1_85/a_2_6# DFFNEGX1_85/a_66_6# vdd pfet w=10 l=2
+  ad=0 pd=0 as=0.15n ps=56u
M1365 AND2X2_8/A DFFNEGX1_85/a_66_6# vdd vdd pfet w=40 l=2
+  ad=0.2n pd=90u as=0 ps=0
M1366 vdd BUFX2_2/Y DFFNEGX1_85/a_2_6# vdd pfet w=40 l=2
+  ad=0 pd=0 as=0.2n ps=90u
M1367 DFFNEGX1_85/a_31_6# DFFNEGX1_85/a_2_6# DFFNEGX1_85/a_23_6# Gnd nfet w=10 l=2
+  ad=0 pd=0 as=0 ps=0
M1368 DFFNEGX1_85/a_66_6# BUFX2_2/Y DFFNEGX1_85/a_61_74# vdd pfet w=20 l=2
+  ad=0 pd=0 as=0 ps=0
M1369 DFFNEGX1_85/a_17_74# OR2X1_18/Y vdd vdd pfet w=20 l=2
+  ad=0 pd=0 as=0 ps=0
M1370 DFFNEGX1_85/a_31_74# BUFX2_2/Y DFFNEGX1_85/a_23_6# vdd pfet w=20 l=2
+  ad=0 pd=0 as=0 ps=0
M1371 DFFNEGX1_85/a_17_6# OR2X1_18/Y gnd Gnd nfet w=10 l=2
+  ad=0 pd=0 as=0 ps=0
M1372 AND2X2_6/a_2_6# invader_2_coord_x[1] vdd vdd pfet w=20 l=2
+  ad=0.12n pd=52u as=0 ps=0
M1373 AND2X2_6/a_9_6# invader_2_coord_x[1] AND2X2_6/a_2_6# Gnd nfet w=20 l=2
+  ad=59.999996p pd=46u as=100p ps=50u
M1374 XOR2X1_7/A AND2X2_6/a_2_6# gnd Gnd nfet w=20 l=2
+  ad=100p pd=50u as=0 ps=0
M1375 XOR2X1_7/A AND2X2_6/a_2_6# vdd vdd pfet w=40 l=2
+  ad=0.2n pd=90u as=0 ps=0
M1376 vdd invader_2_coord_x[2] AND2X2_6/a_2_6# vdd pfet w=20 l=2
+  ad=0 pd=0 as=0 ps=0
M1377 gnd invader_2_coord_x[2] AND2X2_6/a_9_6# Gnd nfet w=20 l=2
+  ad=0 pd=0 as=0 ps=0
M1378 gnd player_bullet_coord_x[1] AOI22X1_1/a_28_6# Gnd nfet w=20 l=2
+  ad=0 pd=0 as=59.999996p ps=46u
M1379 AOI22X1_1/Y invader_2_coord_x[0] AOI22X1_1/a_11_6# Gnd nfet w=20 l=2
+  ad=0.2n pd=60u as=59.999996p ps=46u
M1380 AOI22X1_1/a_11_6# player_bullet_coord_x[0] gnd Gnd nfet w=20 l=2
+  ad=0 pd=0 as=0 ps=0
M1381 AOI22X1_1/a_2_54# invader_2_coord_x[0] vdd vdd pfet w=40 l=2
+  ad=0.64n pd=0.272m as=0 ps=0
M1382 AOI22X1_1/a_28_6# INVX2_45/Y AOI22X1_1/Y Gnd nfet w=20 l=2
+  ad=0 pd=0 as=0 ps=0
M1383 vdd player_bullet_coord_x[0] AOI22X1_1/a_2_54# vdd pfet w=40 l=2
+  ad=0 pd=0 as=0 ps=0
M1384 AOI22X1_1/Y INVX2_45/Y AOI22X1_1/a_2_54# vdd pfet w=40 l=2
+  ad=0.24n pd=92u as=0 ps=0
M1385 AOI22X1_1/a_2_54# player_bullet_coord_x[1] AOI22X1_1/Y vdd pfet w=40 l=2
+  ad=0 pd=0 as=0 ps=0
M1386 INVX2_185/A INVX2_16/A vdd vdd pfet w=20 l=2
+  ad=0.12n pd=52u as=0 ps=0
M1387 NAND2X1_33/a_9_6# INVX2_16/A gnd Gnd nfet w=20 l=2
+  ad=59.999996p pd=46u as=0 ps=0
M1388 vdd NAND2X1_1/B INVX2_185/A vdd pfet w=20 l=2
+  ad=0 pd=0 as=0 ps=0
M1389 INVX2_185/A NAND2X1_1/B NAND2X1_33/a_9_6# Gnd nfet w=20 l=2
+  ad=100p pd=50u as=0 ps=0
M1390 NOR2X1_5/A NOR2X1_6/Y vdd vdd pfet w=20 l=2
+  ad=0.12n pd=52u as=0 ps=0
M1391 NAND2X1_11/a_9_6# NOR2X1_6/Y gnd Gnd nfet w=20 l=2
+  ad=59.999996p pd=46u as=0 ps=0
M1392 vdd INVX2_44/Y NOR2X1_5/A vdd pfet w=20 l=2
+  ad=0 pd=0 as=0 ps=0
M1393 NOR2X1_5/A INVX2_44/Y NAND2X1_11/a_9_6# Gnd nfet w=20 l=2
+  ad=100p pd=50u as=0 ps=0
M1394 NOR2X1_11/A NOR2X1_12/Y vdd vdd pfet w=20 l=2
+  ad=0.12n pd=52u as=0 ps=0
M1395 NAND2X1_22/a_9_6# NOR2X1_12/Y gnd Gnd nfet w=20 l=2
+  ad=59.999996p pd=46u as=0 ps=0
M1396 vdd INVX2_74/Y NOR2X1_11/A vdd pfet w=20 l=2
+  ad=0 pd=0 as=0 ps=0
M1397 NOR2X1_11/A INVX2_74/Y NAND2X1_22/a_9_6# Gnd nfet w=20 l=2
+  ad=100p pd=50u as=0 ps=0
M1398 NAND2X1_55/Y AND2X2_19/Y vdd vdd pfet w=20 l=2
+  ad=0.12n pd=52u as=0 ps=0
M1399 NAND2X1_55/a_9_6# AND2X2_19/Y gnd Gnd nfet w=20 l=2
+  ad=59.999996p pd=46u as=0 ps=0
M1400 vdd INVX2_97/Y NAND2X1_55/Y vdd pfet w=20 l=2
+  ad=0 pd=0 as=0 ps=0
M1401 NAND2X1_55/Y INVX2_97/Y NAND2X1_55/a_9_6# Gnd nfet w=20 l=2
+  ad=100p pd=50u as=0 ps=0
M1402 INVX2_102/A invader_1_coord_x[0] vdd vdd pfet w=20 l=2
+  ad=0.12n pd=52u as=0 ps=0
M1403 NAND2X1_77/a_9_6# invader_1_coord_x[0] gnd Gnd nfet w=20 l=2
+  ad=59.999996p pd=46u as=0 ps=0
M1404 vdd INVX2_176/Y INVX2_102/A vdd pfet w=20 l=2
+  ad=0 pd=0 as=0 ps=0
M1405 INVX2_102/A INVX2_176/Y NAND2X1_77/a_9_6# Gnd nfet w=20 l=2
+  ad=100p pd=50u as=0 ps=0
M1406 OAI22X1_9/C INVX2_100/A vdd vdd pfet w=20 l=2
+  ad=0.12n pd=52u as=0 ps=0
M1407 NAND2X1_66/a_9_6# INVX2_100/A gnd Gnd nfet w=20 l=2
+  ad=59.999996p pd=46u as=0 ps=0
M1408 vdd INVX2_102/A OAI22X1_9/C vdd pfet w=20 l=2
+  ad=0 pd=0 as=0 ps=0
M1409 OAI22X1_9/C INVX2_102/A NAND2X1_66/a_9_6# Gnd nfet w=20 l=2
+  ad=100p pd=50u as=0 ps=0
M1410 OAI21X1_88/B INVX2_59/A vdd vdd pfet w=20 l=2
+  ad=0.12n pd=52u as=0 ps=0
M1411 NAND2X1_44/a_9_6# INVX2_59/A gnd Gnd nfet w=20 l=2
+  ad=59.999996p pd=46u as=0 ps=0
M1412 vdd INVX2_144/Y OAI21X1_88/B vdd pfet w=20 l=2
+  ad=0 pd=0 as=0 ps=0
M1413 OAI21X1_88/B INVX2_144/Y NAND2X1_44/a_9_6# Gnd nfet w=20 l=2
+  ad=100p pd=50u as=0 ps=0
M1414 gnd player_coord_x[0] AOI22X1_42/a_28_6# Gnd nfet w=20 l=2
+  ad=0 pd=0 as=59.999996p ps=46u
M1415 NAND2X1_53/A AOI22X1_42/B AOI22X1_42/a_11_6# Gnd nfet w=20 l=2
+  ad=0.2n pd=60u as=59.999996p ps=46u
M1416 AOI22X1_42/a_11_6# INVX2_97/A gnd Gnd nfet w=20 l=2
+  ad=0 pd=0 as=0 ps=0
M1417 AOI22X1_42/a_2_54# AOI22X1_42/B vdd vdd pfet w=40 l=2
+  ad=0.64n pd=0.272m as=0 ps=0
M1418 AOI22X1_42/a_28_6# INVX2_164/A NAND2X1_53/A Gnd nfet w=20 l=2
+  ad=0 pd=0 as=0 ps=0
M1419 vdd INVX2_97/A AOI22X1_42/a_2_54# vdd pfet w=40 l=2
+  ad=0 pd=0 as=0 ps=0
M1420 NAND2X1_53/A INVX2_164/A AOI22X1_42/a_2_54# vdd pfet w=40 l=2
+  ad=0.24n pd=92u as=0 ps=0
M1421 AOI22X1_42/a_2_54# player_coord_x[0] NAND2X1_53/A vdd pfet w=40 l=2
+  ad=0 pd=0 as=0 ps=0
M1422 gnd INVX2_152/A AOI22X1_20/a_28_6# Gnd nfet w=20 l=2
+  ad=0 pd=0 as=59.999996p ps=46u
M1423 NOR2X1_19/A NOR2X1_20/Y AOI22X1_20/a_11_6# Gnd nfet w=20 l=2
+  ad=0.2n pd=60u as=59.999996p ps=46u
M1424 AOI22X1_20/a_11_6# NOR2X1_21/Y gnd Gnd nfet w=20 l=2
+  ad=0 pd=0 as=0 ps=0
M1425 AOI22X1_20/a_2_54# NOR2X1_20/Y vdd vdd pfet w=40 l=2
+  ad=0.64n pd=0.272m as=0 ps=0
M1426 AOI22X1_20/a_28_6# INVX2_10/Y NOR2X1_19/A Gnd nfet w=20 l=2
+  ad=0 pd=0 as=0 ps=0
M1427 vdd NOR2X1_21/Y AOI22X1_20/a_2_54# vdd pfet w=40 l=2
+  ad=0 pd=0 as=0 ps=0
M1428 NOR2X1_19/A INVX2_10/Y AOI22X1_20/a_2_54# vdd pfet w=40 l=2
+  ad=0.24n pd=92u as=0 ps=0
M1429 AOI22X1_20/a_2_54# INVX2_152/A NOR2X1_19/A vdd pfet w=40 l=2
+  ad=0 pd=0 as=0 ps=0
M1430 gnd NAND2X1_24/Y AOI22X1_31/a_28_6# Gnd nfet w=20 l=2
+  ad=0 pd=0 as=59.999996p ps=46u
M1431 OAI21X1_72/C AND2X2_13/Y AOI22X1_31/a_11_6# Gnd nfet w=20 l=2
+  ad=0.2n pd=60u as=59.999996p ps=46u
M1432 AOI22X1_31/a_11_6# AND2X2_11/Y gnd Gnd nfet w=20 l=2
+  ad=0 pd=0 as=0 ps=0
M1433 AOI22X1_31/a_2_54# AND2X2_13/Y vdd vdd pfet w=40 l=2
+  ad=0.64n pd=0.272m as=0 ps=0
M1434 AOI22X1_31/a_28_6# AND2X2_12/Y OAI21X1_72/C Gnd nfet w=20 l=2
+  ad=0 pd=0 as=0 ps=0
M1435 vdd AND2X2_11/Y AOI22X1_31/a_2_54# vdd pfet w=40 l=2
+  ad=0 pd=0 as=0 ps=0
M1436 OAI21X1_72/C AND2X2_12/Y AOI22X1_31/a_2_54# vdd pfet w=40 l=2
+  ad=0.24n pd=92u as=0 ps=0
M1437 AOI22X1_31/a_2_54# NAND2X1_24/Y OAI21X1_72/C vdd pfet w=40 l=2
+  ad=0 pd=0 as=0 ps=0
M1438 gnd invader_2_coord_y[3] AOI22X1_53/a_28_6# Gnd nfet w=20 l=2
+  ad=0 pd=0 as=59.999996p ps=46u
M1439 INVX2_116/A OAI22X1_8/A AOI22X1_53/a_11_6# Gnd nfet w=20 l=2
+  ad=0.2n pd=60u as=59.999996p ps=46u
M1440 AOI22X1_53/a_11_6# invader_1_coord_y[3] gnd Gnd nfet w=20 l=2
+  ad=0 pd=0 as=0 ps=0
M1441 AOI22X1_53/a_2_54# OAI22X1_8/A vdd vdd pfet w=40 l=2
+  ad=0.64n pd=0.272m as=0 ps=0
M1442 AOI22X1_53/a_28_6# OAI22X1_8/D INVX2_116/A Gnd nfet w=20 l=2
+  ad=0 pd=0 as=0 ps=0
M1443 vdd invader_1_coord_y[3] AOI22X1_53/a_2_54# vdd pfet w=40 l=2
+  ad=0 pd=0 as=0 ps=0
M1444 INVX2_116/A OAI22X1_8/D AOI22X1_53/a_2_54# vdd pfet w=40 l=2
+  ad=0.24n pd=92u as=0 ps=0
M1445 AOI22X1_53/a_2_54# invader_2_coord_y[3] INVX2_116/A vdd pfet w=40 l=2
+  ad=0 pd=0 as=0 ps=0
M1446 gnd INVX2_32/Y OAI22X1_4/a_2_6# Gnd nfet w=20 l=2
+  ad=0 pd=0 as=0.32n ps=0.152m
M1447 OAI22X1_4/a_2_6# INVX2_32/A OAI22X1_4/Y Gnd nfet w=20 l=2
+  ad=0 pd=0 as=0.12n ps=52u
M1448 OAI22X1_4/Y OAI22X1_4/D OAI22X1_4/a_2_6# Gnd nfet w=20 l=2
+  ad=0 pd=0 as=0 ps=0
M1449 OAI22X1_4/Y OAI22X1_4/B OAI22X1_4/a_9_54# vdd pfet w=40 l=2
+  ad=0.48n pd=0.104m as=0.12n ps=86u
M1450 OAI22X1_4/a_28_54# OAI22X1_4/D OAI22X1_4/Y vdd pfet w=40 l=2
+  ad=0.12n pd=86u as=0 ps=0
M1451 OAI22X1_4/a_9_54# INVX2_32/Y vdd vdd pfet w=40 l=2
+  ad=0 pd=0 as=0 ps=0
M1452 OAI22X1_4/a_2_6# OAI22X1_4/B gnd Gnd nfet w=20 l=2
+  ad=0 pd=0 as=0 ps=0
M1453 vdd INVX2_32/A OAI22X1_4/a_28_54# vdd pfet w=40 l=2
+  ad=0 pd=0 as=0 ps=0
M1454 INVX2_24/Y INVX2_24/A gnd Gnd nfet w=20 l=2
+  ad=100p pd=50u as=0 ps=0
M1455 INVX2_24/Y INVX2_24/A vdd vdd pfet w=40 l=2
+  ad=0.2n pd=90u as=0 ps=0
M1456 NOR2X1_2/A INVX2_13/A gnd Gnd nfet w=20 l=2
+  ad=100p pd=50u as=0 ps=0
M1457 NOR2X1_2/A INVX2_13/A vdd vdd pfet w=40 l=2
+  ad=0.2n pd=90u as=0 ps=0
M1458 INVX2_35/Y INVX2_35/A gnd Gnd nfet w=20 l=2
+  ad=100p pd=50u as=0 ps=0
M1459 INVX2_35/Y INVX2_35/A vdd vdd pfet w=40 l=2
+  ad=0.2n pd=90u as=0 ps=0
M1460 INVX2_79/Y INVX2_79/A gnd Gnd nfet w=20 l=2
+  ad=100p pd=50u as=0 ps=0
M1461 INVX2_79/Y INVX2_79/A vdd vdd pfet w=40 l=2
+  ad=0.2n pd=90u as=0 ps=0
M1462 INVX2_46/Y INVX2_46/A gnd Gnd nfet w=20 l=2
+  ad=100p pd=50u as=0 ps=0
M1463 INVX2_46/Y INVX2_46/A vdd vdd pfet w=40 l=2
+  ad=0.2n pd=90u as=0 ps=0
M1464 INVX2_68/Y INVX2_68/A gnd Gnd nfet w=20 l=2
+  ad=100p pd=50u as=0 ps=0
M1465 INVX2_68/Y INVX2_68/A vdd vdd pfet w=40 l=2
+  ad=0.2n pd=90u as=0 ps=0
M1466 INVX2_57/Y INVX2_57/A gnd Gnd nfet w=20 l=2
+  ad=100p pd=50u as=0 ps=0
M1467 INVX2_57/Y INVX2_57/A vdd vdd pfet w=40 l=2
+  ad=0.2n pd=90u as=0 ps=0
M1468 OAI22X1_7/C invader_1_coord_x[1] gnd Gnd nfet w=20 l=2
+  ad=100p pd=50u as=0 ps=0
M1469 OAI22X1_7/C invader_1_coord_x[1] vdd vdd pfet w=40 l=2
+  ad=0.2n pd=90u as=0 ps=0
M1470 gnd XNOR2X1_8/B XNOR2X1_7/a_2_6# Gnd nfet w=20 l=2
+  ad=0 pd=0 as=100p ps=50u
M1471 XNOR2X1_7/Y XNOR2X1_8/B XNOR2X1_7/a_18_6# Gnd nfet w=20 l=2
+  ad=0.2n pd=60u as=59.999996p ps=46u
M1472 XNOR2X1_7/a_12_41# XNOR2X1_7/B gnd Gnd nfet w=20 l=2
+  ad=100p pd=50u as=0 ps=0
M1473 XNOR2X1_7/a_18_54# XNOR2X1_7/a_12_41# vdd vdd pfet w=40 l=2
+  ad=0.12n pd=86u as=0 ps=0
M1474 XNOR2X1_7/a_35_6# XNOR2X1_7/a_2_6# XNOR2X1_7/Y Gnd nfet w=20 l=2
+  ad=59.999996p pd=46u as=0 ps=0
M1475 XNOR2X1_7/a_18_6# XNOR2X1_7/a_12_41# gnd Gnd nfet w=20 l=2
+  ad=0 pd=0 as=0 ps=0
M1476 vdd XNOR2X1_8/B XNOR2X1_7/a_2_6# vdd pfet w=40 l=2
+  ad=0 pd=0 as=0.2n ps=90u
M1477 vdd XNOR2X1_7/B XNOR2X1_7/a_35_54# vdd pfet w=40 l=2
+  ad=0 pd=0 as=0.12n ps=86u
M1478 XNOR2X1_7/Y XNOR2X1_7/a_2_6# XNOR2X1_7/a_18_54# vdd pfet w=40 l=2
+  ad=0.4n pd=100u as=0 ps=0
M1479 XNOR2X1_7/a_35_54# XNOR2X1_8/B XNOR2X1_7/Y vdd pfet w=40 l=2
+  ad=0 pd=0 as=0 ps=0
M1480 XNOR2X1_7/a_12_41# XNOR2X1_7/B vdd vdd pfet w=40 l=2
+  ad=0.2n pd=90u as=0 ps=0
M1481 gnd XNOR2X1_7/B XNOR2X1_7/a_35_6# Gnd nfet w=20 l=2
+  ad=0 pd=0 as=0 ps=0
M1482 DFFNEGX1_20/a_76_6# BUFX2_6/Y DFFNEGX1_20/a_66_6# Gnd nfet w=10 l=2
+  ad=29.999998p pd=26u as=80p ps=36u
M1483 gnd BUFX2_6/Y DFFNEGX1_20/a_2_6# Gnd nfet w=20 l=2
+  ad=0 pd=0 as=100p ps=50u
M1484 DFFNEGX1_20/a_66_6# DFFNEGX1_20/a_2_6# DFFNEGX1_20/a_61_6# Gnd nfet w=10 l=2
+  ad=0 pd=0 as=29.999998p ps=26u
M1485 player_bullet_coord_y[1] DFFNEGX1_20/a_66_6# gnd Gnd nfet w=20 l=2
+  ad=100p pd=50u as=0 ps=0
M1486 DFFNEGX1_20/a_23_6# BUFX2_6/Y DFFNEGX1_20/a_17_6# Gnd nfet w=10 l=2
+  ad=59.999996p pd=32u as=40p ps=28u
M1487 DFFNEGX1_20/a_23_6# DFFNEGX1_20/a_2_6# DFFNEGX1_20/a_17_74# vdd pfet w=20 l=2
+  ad=0.12n pd=52u as=80p ps=48u
M1488 gnd DFFNEGX1_20/a_34_4# DFFNEGX1_20/a_31_6# Gnd nfet w=10 l=2
+  ad=0 pd=0 as=29.999998p ps=26u
M1489 vdd DFFNEGX1_20/a_34_4# DFFNEGX1_20/a_31_74# vdd pfet w=20 l=2
+  ad=0 pd=0 as=80p ps=48u
M1490 DFFNEGX1_20/a_61_74# DFFNEGX1_20/a_34_4# vdd vdd pfet w=20 l=2
+  ad=59.999996p pd=46u as=0 ps=0
M1491 DFFNEGX1_20/a_34_4# DFFNEGX1_20/a_23_6# vdd vdd pfet w=20 l=2
+  ad=100p pd=50u as=0 ps=0
M1492 DFFNEGX1_20/a_34_4# DFFNEGX1_20/a_23_6# gnd Gnd nfet w=10 l=2
+  ad=50p pd=30u as=0 ps=0
M1493 vdd player_bullet_coord_y[1] DFFNEGX1_20/a_76_84# vdd pfet w=10 l=2
+  ad=0 pd=0 as=29.999998p ps=26u
M1494 gnd player_bullet_coord_y[1] DFFNEGX1_20/a_76_6# Gnd nfet w=10 l=2
+  ad=0 pd=0 as=0 ps=0
M1495 DFFNEGX1_20/a_61_6# DFFNEGX1_20/a_34_4# gnd Gnd nfet w=10 l=2
+  ad=0 pd=0 as=0 ps=0
M1496 DFFNEGX1_20/a_76_84# DFFNEGX1_20/a_2_6# DFFNEGX1_20/a_66_6# vdd pfet w=10 l=2
+  ad=0 pd=0 as=0.15n ps=56u
M1497 player_bullet_coord_y[1] DFFNEGX1_20/a_66_6# vdd vdd pfet w=40 l=2
+  ad=0.2n pd=90u as=0 ps=0
M1498 vdd BUFX2_6/Y DFFNEGX1_20/a_2_6# vdd pfet w=40 l=2
+  ad=0 pd=0 as=0.2n ps=90u
M1499 DFFNEGX1_20/a_31_6# DFFNEGX1_20/a_2_6# DFFNEGX1_20/a_23_6# Gnd nfet w=10 l=2
+  ad=0 pd=0 as=0 ps=0
M1500 DFFNEGX1_20/a_66_6# BUFX2_6/Y DFFNEGX1_20/a_61_74# vdd pfet w=20 l=2
+  ad=0 pd=0 as=0 ps=0
M1501 DFFNEGX1_20/a_17_74# NAND2X1_3/Y vdd vdd pfet w=20 l=2
+  ad=0 pd=0 as=0 ps=0
M1502 DFFNEGX1_20/a_31_74# BUFX2_6/Y DFFNEGX1_20/a_23_6# vdd pfet w=20 l=2
+  ad=0 pd=0 as=0 ps=0
M1503 DFFNEGX1_20/a_17_6# NAND2X1_3/Y gnd Gnd nfet w=10 l=2
+  ad=0 pd=0 as=0 ps=0
M1504 DFFNEGX1_31/a_76_6# BUFX2_5/Y DFFNEGX1_31/a_66_6# Gnd nfet w=10 l=2
+  ad=29.999998p pd=26u as=80p ps=36u
M1505 gnd BUFX2_5/Y DFFNEGX1_31/a_2_6# Gnd nfet w=20 l=2
+  ad=0 pd=0 as=100p ps=50u
M1506 DFFNEGX1_31/a_66_6# DFFNEGX1_31/a_2_6# DFFNEGX1_31/a_61_6# Gnd nfet w=10 l=2
+  ad=0 pd=0 as=29.999998p ps=26u
M1507 invader_2_coord_y[0] DFFNEGX1_31/a_66_6# gnd Gnd nfet w=20 l=2
+  ad=100p pd=50u as=0 ps=0
M1508 DFFNEGX1_31/a_23_6# BUFX2_5/Y DFFNEGX1_31/a_17_6# Gnd nfet w=10 l=2
+  ad=59.999996p pd=32u as=40p ps=28u
M1509 DFFNEGX1_31/a_23_6# DFFNEGX1_31/a_2_6# DFFNEGX1_31/a_17_74# vdd pfet w=20 l=2
+  ad=0.12n pd=52u as=80p ps=48u
M1510 gnd DFFNEGX1_31/a_34_4# DFFNEGX1_31/a_31_6# Gnd nfet w=10 l=2
+  ad=0 pd=0 as=29.999998p ps=26u
M1511 vdd DFFNEGX1_31/a_34_4# DFFNEGX1_31/a_31_74# vdd pfet w=20 l=2
+  ad=0 pd=0 as=80p ps=48u
M1512 DFFNEGX1_31/a_61_74# DFFNEGX1_31/a_34_4# vdd vdd pfet w=20 l=2
+  ad=59.999996p pd=46u as=0 ps=0
M1513 DFFNEGX1_31/a_34_4# DFFNEGX1_31/a_23_6# vdd vdd pfet w=20 l=2
+  ad=100p pd=50u as=0 ps=0
M1514 DFFNEGX1_31/a_34_4# DFFNEGX1_31/a_23_6# gnd Gnd nfet w=10 l=2
+  ad=50p pd=30u as=0 ps=0
M1515 vdd invader_2_coord_y[0] DFFNEGX1_31/a_76_84# vdd pfet w=10 l=2
+  ad=0 pd=0 as=29.999998p ps=26u
M1516 gnd invader_2_coord_y[0] DFFNEGX1_31/a_76_6# Gnd nfet w=10 l=2
+  ad=0 pd=0 as=0 ps=0
M1517 DFFNEGX1_31/a_61_6# DFFNEGX1_31/a_34_4# gnd Gnd nfet w=10 l=2
+  ad=0 pd=0 as=0 ps=0
M1518 DFFNEGX1_31/a_76_84# DFFNEGX1_31/a_2_6# DFFNEGX1_31/a_66_6# vdd pfet w=10 l=2
+  ad=0 pd=0 as=0.15n ps=56u
M1519 invader_2_coord_y[0] DFFNEGX1_31/a_66_6# vdd vdd pfet w=40 l=2
+  ad=0.2n pd=90u as=0 ps=0
M1520 vdd BUFX2_5/Y DFFNEGX1_31/a_2_6# vdd pfet w=40 l=2
+  ad=0 pd=0 as=0.2n ps=90u
M1521 DFFNEGX1_31/a_31_6# DFFNEGX1_31/a_2_6# DFFNEGX1_31/a_23_6# Gnd nfet w=10 l=2
+  ad=0 pd=0 as=0 ps=0
M1522 DFFNEGX1_31/a_66_6# BUFX2_5/Y DFFNEGX1_31/a_61_74# vdd pfet w=20 l=2
+  ad=0 pd=0 as=0 ps=0
M1523 DFFNEGX1_31/a_17_74# OR2X1_8/Y vdd vdd pfet w=20 l=2
+  ad=0 pd=0 as=0 ps=0
M1524 DFFNEGX1_31/a_31_74# BUFX2_5/Y DFFNEGX1_31/a_23_6# vdd pfet w=20 l=2
+  ad=0 pd=0 as=0 ps=0
M1525 DFFNEGX1_31/a_17_6# OR2X1_8/Y gnd Gnd nfet w=10 l=2
+  ad=0 pd=0 as=0 ps=0
M1526 DFFNEGX1_42/a_76_6# BUFX2_5/Y DFFNEGX1_42/a_66_6# Gnd nfet w=10 l=2
+  ad=29.999998p pd=26u as=80p ps=36u
M1527 gnd BUFX2_5/Y DFFNEGX1_42/a_2_6# Gnd nfet w=20 l=2
+  ad=0 pd=0 as=100p ps=50u
M1528 DFFNEGX1_42/a_66_6# DFFNEGX1_42/a_2_6# DFFNEGX1_42/a_61_6# Gnd nfet w=10 l=2
+  ad=0 pd=0 as=29.999998p ps=26u
M1529 INVX2_58/A DFFNEGX1_42/a_66_6# gnd Gnd nfet w=20 l=2
+  ad=100p pd=50u as=0 ps=0
M1530 DFFNEGX1_42/a_23_6# BUFX2_5/Y DFFNEGX1_42/a_17_6# Gnd nfet w=10 l=2
+  ad=59.999996p pd=32u as=40p ps=28u
M1531 DFFNEGX1_42/a_23_6# DFFNEGX1_42/a_2_6# DFFNEGX1_42/a_17_74# vdd pfet w=20 l=2
+  ad=0.12n pd=52u as=80p ps=48u
M1532 gnd DFFNEGX1_42/a_34_4# DFFNEGX1_42/a_31_6# Gnd nfet w=10 l=2
+  ad=0 pd=0 as=29.999998p ps=26u
M1533 vdd DFFNEGX1_42/a_34_4# DFFNEGX1_42/a_31_74# vdd pfet w=20 l=2
+  ad=0 pd=0 as=80p ps=48u
M1534 DFFNEGX1_42/a_61_74# DFFNEGX1_42/a_34_4# vdd vdd pfet w=20 l=2
+  ad=59.999996p pd=46u as=0 ps=0
M1535 DFFNEGX1_42/a_34_4# DFFNEGX1_42/a_23_6# vdd vdd pfet w=20 l=2
+  ad=100p pd=50u as=0 ps=0
M1536 DFFNEGX1_42/a_34_4# DFFNEGX1_42/a_23_6# gnd Gnd nfet w=10 l=2
+  ad=50p pd=30u as=0 ps=0
M1537 vdd INVX2_58/A DFFNEGX1_42/a_76_84# vdd pfet w=10 l=2
+  ad=0 pd=0 as=29.999998p ps=26u
M1538 gnd INVX2_58/A DFFNEGX1_42/a_76_6# Gnd nfet w=10 l=2
+  ad=0 pd=0 as=0 ps=0
M1539 DFFNEGX1_42/a_61_6# DFFNEGX1_42/a_34_4# gnd Gnd nfet w=10 l=2
+  ad=0 pd=0 as=0 ps=0
M1540 DFFNEGX1_42/a_76_84# DFFNEGX1_42/a_2_6# DFFNEGX1_42/a_66_6# vdd pfet w=10 l=2
+  ad=0 pd=0 as=0.15n ps=56u
M1541 INVX2_58/A DFFNEGX1_42/a_66_6# vdd vdd pfet w=40 l=2
+  ad=0.2n pd=90u as=0 ps=0
M1542 vdd BUFX2_5/Y DFFNEGX1_42/a_2_6# vdd pfet w=40 l=2
+  ad=0 pd=0 as=0.2n ps=90u
M1543 DFFNEGX1_42/a_31_6# DFFNEGX1_42/a_2_6# DFFNEGX1_42/a_23_6# Gnd nfet w=10 l=2
+  ad=0 pd=0 as=0 ps=0
M1544 DFFNEGX1_42/a_66_6# BUFX2_5/Y DFFNEGX1_42/a_61_74# vdd pfet w=20 l=2
+  ad=0 pd=0 as=0 ps=0
M1545 DFFNEGX1_42/a_17_74# OAI21X1_76/Y vdd vdd pfet w=20 l=2
+  ad=0 pd=0 as=0 ps=0
M1546 DFFNEGX1_42/a_31_74# BUFX2_5/Y DFFNEGX1_42/a_23_6# vdd pfet w=20 l=2
+  ad=0 pd=0 as=0 ps=0
M1547 DFFNEGX1_42/a_17_6# OAI21X1_76/Y gnd Gnd nfet w=10 l=2
+  ad=0 pd=0 as=0 ps=0
M1548 DFFNEGX1_75/a_76_6# BUFX2_2/Y DFFNEGX1_75/a_66_6# Gnd nfet w=10 l=2
+  ad=29.999998p pd=26u as=80p ps=36u
M1549 gnd BUFX2_2/Y DFFNEGX1_75/a_2_6# Gnd nfet w=20 l=2
+  ad=0 pd=0 as=100p ps=50u
M1550 DFFNEGX1_75/a_66_6# DFFNEGX1_75/a_2_6# DFFNEGX1_75/a_61_6# Gnd nfet w=10 l=2
+  ad=0 pd=0 as=29.999998p ps=26u
M1551 player_display DFFNEGX1_75/a_66_6# gnd Gnd nfet w=20 l=2
+  ad=100p pd=50u as=0 ps=0
M1552 DFFNEGX1_75/a_23_6# BUFX2_2/Y DFFNEGX1_75/a_17_6# Gnd nfet w=10 l=2
+  ad=59.999996p pd=32u as=40p ps=28u
M1553 DFFNEGX1_75/a_23_6# DFFNEGX1_75/a_2_6# DFFNEGX1_75/a_17_74# vdd pfet w=20 l=2
+  ad=0.12n pd=52u as=80p ps=48u
M1554 gnd DFFNEGX1_75/a_34_4# DFFNEGX1_75/a_31_6# Gnd nfet w=10 l=2
+  ad=0 pd=0 as=29.999998p ps=26u
M1555 vdd DFFNEGX1_75/a_34_4# DFFNEGX1_75/a_31_74# vdd pfet w=20 l=2
+  ad=0 pd=0 as=80p ps=48u
M1556 DFFNEGX1_75/a_61_74# DFFNEGX1_75/a_34_4# vdd vdd pfet w=20 l=2
+  ad=59.999996p pd=46u as=0 ps=0
M1557 DFFNEGX1_75/a_34_4# DFFNEGX1_75/a_23_6# vdd vdd pfet w=20 l=2
+  ad=100p pd=50u as=0 ps=0
M1558 DFFNEGX1_75/a_34_4# DFFNEGX1_75/a_23_6# gnd Gnd nfet w=10 l=2
+  ad=50p pd=30u as=0 ps=0
M1559 vdd player_display DFFNEGX1_75/a_76_84# vdd pfet w=10 l=2
+  ad=0 pd=0 as=29.999998p ps=26u
M1560 gnd player_display DFFNEGX1_75/a_76_6# Gnd nfet w=10 l=2
+  ad=0 pd=0 as=0 ps=0
M1561 DFFNEGX1_75/a_61_6# DFFNEGX1_75/a_34_4# gnd Gnd nfet w=10 l=2
+  ad=0 pd=0 as=0 ps=0
M1562 DFFNEGX1_75/a_76_84# DFFNEGX1_75/a_2_6# DFFNEGX1_75/a_66_6# vdd pfet w=10 l=2
+  ad=0 pd=0 as=0.15n ps=56u
M1563 player_display DFFNEGX1_75/a_66_6# vdd vdd pfet w=40 l=2
+  ad=0.2n pd=90u as=0 ps=0
M1564 vdd BUFX2_2/Y DFFNEGX1_75/a_2_6# vdd pfet w=40 l=2
+  ad=0 pd=0 as=0.2n ps=90u
M1565 DFFNEGX1_75/a_31_6# DFFNEGX1_75/a_2_6# DFFNEGX1_75/a_23_6# Gnd nfet w=10 l=2
+  ad=0 pd=0 as=0 ps=0
M1566 DFFNEGX1_75/a_66_6# BUFX2_2/Y DFFNEGX1_75/a_61_74# vdd pfet w=20 l=2
+  ad=0 pd=0 as=0 ps=0
M1567 DFFNEGX1_75/a_17_74# NAND2X1_55/Y vdd vdd pfet w=20 l=2
+  ad=0 pd=0 as=0 ps=0
M1568 DFFNEGX1_75/a_31_74# BUFX2_2/Y DFFNEGX1_75/a_23_6# vdd pfet w=20 l=2
+  ad=0 pd=0 as=0 ps=0
M1569 DFFNEGX1_75/a_17_6# NAND2X1_55/Y gnd Gnd nfet w=10 l=2
+  ad=0 pd=0 as=0 ps=0
M1570 DFFNEGX1_86/a_76_6# clka DFFNEGX1_86/a_66_6# Gnd nfet w=10 l=2
+  ad=29.999998p pd=26u as=80p ps=36u
M1571 gnd clka DFFNEGX1_86/a_2_6# Gnd nfet w=20 l=2
+  ad=0 pd=0 as=100p ps=50u
M1572 DFFNEGX1_86/a_66_6# DFFNEGX1_86/a_2_6# DFFNEGX1_86/a_61_6# Gnd nfet w=10 l=2
+  ad=0 pd=0 as=29.999998p ps=26u
M1573 AOI22X1_48/A DFFNEGX1_86/a_66_6# gnd Gnd nfet w=20 l=2
+  ad=100p pd=50u as=0 ps=0
M1574 DFFNEGX1_86/a_23_6# clka DFFNEGX1_86/a_17_6# Gnd nfet w=10 l=2
+  ad=59.999996p pd=32u as=40p ps=28u
M1575 DFFNEGX1_86/a_23_6# DFFNEGX1_86/a_2_6# DFFNEGX1_86/a_17_74# vdd pfet w=20 l=2
+  ad=0.12n pd=52u as=80p ps=48u
M1576 gnd DFFNEGX1_86/a_34_4# DFFNEGX1_86/a_31_6# Gnd nfet w=10 l=2
+  ad=0 pd=0 as=29.999998p ps=26u
M1577 vdd DFFNEGX1_86/a_34_4# DFFNEGX1_86/a_31_74# vdd pfet w=20 l=2
+  ad=0 pd=0 as=80p ps=48u
M1578 DFFNEGX1_86/a_61_74# DFFNEGX1_86/a_34_4# vdd vdd pfet w=20 l=2
+  ad=59.999996p pd=46u as=0 ps=0
M1579 DFFNEGX1_86/a_34_4# DFFNEGX1_86/a_23_6# vdd vdd pfet w=20 l=2
+  ad=100p pd=50u as=0 ps=0
M1580 DFFNEGX1_86/a_34_4# DFFNEGX1_86/a_23_6# gnd Gnd nfet w=10 l=2
+  ad=50p pd=30u as=0 ps=0
M1581 vdd AOI22X1_48/A DFFNEGX1_86/a_76_84# vdd pfet w=10 l=2
+  ad=0 pd=0 as=29.999998p ps=26u
M1582 gnd AOI22X1_48/A DFFNEGX1_86/a_76_6# Gnd nfet w=10 l=2
+  ad=0 pd=0 as=0 ps=0
M1583 DFFNEGX1_86/a_61_6# DFFNEGX1_86/a_34_4# gnd Gnd nfet w=10 l=2
+  ad=0 pd=0 as=0 ps=0
M1584 DFFNEGX1_86/a_76_84# DFFNEGX1_86/a_2_6# DFFNEGX1_86/a_66_6# vdd pfet w=10 l=2
+  ad=0 pd=0 as=0.15n ps=56u
M1585 AOI22X1_48/A DFFNEGX1_86/a_66_6# vdd vdd pfet w=40 l=2
+  ad=0.2n pd=90u as=0 ps=0
M1586 vdd clka DFFNEGX1_86/a_2_6# vdd pfet w=40 l=2
+  ad=0 pd=0 as=0.2n ps=90u
M1587 DFFNEGX1_86/a_31_6# DFFNEGX1_86/a_2_6# DFFNEGX1_86/a_23_6# Gnd nfet w=10 l=2
+  ad=0 pd=0 as=0 ps=0
M1588 DFFNEGX1_86/a_66_6# clka DFFNEGX1_86/a_61_74# vdd pfet w=20 l=2
+  ad=0 pd=0 as=0 ps=0
M1589 DFFNEGX1_86/a_17_74# AND2X2_20/Y vdd vdd pfet w=20 l=2
+  ad=0 pd=0 as=0 ps=0
M1590 DFFNEGX1_86/a_31_74# clka DFFNEGX1_86/a_23_6# vdd pfet w=20 l=2
+  ad=0 pd=0 as=0 ps=0
M1591 DFFNEGX1_86/a_17_6# AND2X2_20/Y gnd Gnd nfet w=10 l=2
+  ad=0 pd=0 as=0 ps=0
M1592 DFFNEGX1_64/a_76_6# BUFX2_3/Y DFFNEGX1_64/a_66_6# Gnd nfet w=10 l=2
+  ad=29.999998p pd=26u as=80p ps=36u
M1593 gnd BUFX2_3/Y DFFNEGX1_64/a_2_6# Gnd nfet w=20 l=2
+  ad=0 pd=0 as=100p ps=50u
M1594 DFFNEGX1_64/a_66_6# DFFNEGX1_64/a_2_6# DFFNEGX1_64/a_61_6# Gnd nfet w=10 l=2
+  ad=0 pd=0 as=29.999998p ps=26u
M1595 NOR2X1_20/A DFFNEGX1_64/a_66_6# gnd Gnd nfet w=20 l=2
+  ad=100p pd=50u as=0 ps=0
M1596 DFFNEGX1_64/a_23_6# BUFX2_3/Y DFFNEGX1_64/a_17_6# Gnd nfet w=10 l=2
+  ad=59.999996p pd=32u as=40p ps=28u
M1597 DFFNEGX1_64/a_23_6# DFFNEGX1_64/a_2_6# DFFNEGX1_64/a_17_74# vdd pfet w=20 l=2
+  ad=0.12n pd=52u as=80p ps=48u
M1598 gnd DFFNEGX1_64/a_34_4# DFFNEGX1_64/a_31_6# Gnd nfet w=10 l=2
+  ad=0 pd=0 as=29.999998p ps=26u
M1599 vdd DFFNEGX1_64/a_34_4# DFFNEGX1_64/a_31_74# vdd pfet w=20 l=2
+  ad=0 pd=0 as=80p ps=48u
M1600 DFFNEGX1_64/a_61_74# DFFNEGX1_64/a_34_4# vdd vdd pfet w=20 l=2
+  ad=59.999996p pd=46u as=0 ps=0
M1601 DFFNEGX1_64/a_34_4# DFFNEGX1_64/a_23_6# vdd vdd pfet w=20 l=2
+  ad=100p pd=50u as=0 ps=0
M1602 DFFNEGX1_64/a_34_4# DFFNEGX1_64/a_23_6# gnd Gnd nfet w=10 l=2
+  ad=50p pd=30u as=0 ps=0
M1603 vdd NOR2X1_20/A DFFNEGX1_64/a_76_84# vdd pfet w=10 l=2
+  ad=0 pd=0 as=29.999998p ps=26u
M1604 gnd NOR2X1_20/A DFFNEGX1_64/a_76_6# Gnd nfet w=10 l=2
+  ad=0 pd=0 as=0 ps=0
M1605 DFFNEGX1_64/a_61_6# DFFNEGX1_64/a_34_4# gnd Gnd nfet w=10 l=2
+  ad=0 pd=0 as=0 ps=0
M1606 DFFNEGX1_64/a_76_84# DFFNEGX1_64/a_2_6# DFFNEGX1_64/a_66_6# vdd pfet w=10 l=2
+  ad=0 pd=0 as=0.15n ps=56u
M1607 NOR2X1_20/A DFFNEGX1_64/a_66_6# vdd vdd pfet w=40 l=2
+  ad=0.2n pd=90u as=0 ps=0
M1608 vdd BUFX2_3/Y DFFNEGX1_64/a_2_6# vdd pfet w=40 l=2
+  ad=0 pd=0 as=0.2n ps=90u
M1609 DFFNEGX1_64/a_31_6# DFFNEGX1_64/a_2_6# DFFNEGX1_64/a_23_6# Gnd nfet w=10 l=2
+  ad=0 pd=0 as=0 ps=0
M1610 DFFNEGX1_64/a_66_6# BUFX2_3/Y DFFNEGX1_64/a_61_74# vdd pfet w=20 l=2
+  ad=0 pd=0 as=0 ps=0
M1611 DFFNEGX1_64/a_17_74# OAI21X1_93/Y vdd vdd pfet w=20 l=2
+  ad=0 pd=0 as=0 ps=0
M1612 DFFNEGX1_64/a_31_74# BUFX2_3/Y DFFNEGX1_64/a_23_6# vdd pfet w=20 l=2
+  ad=0 pd=0 as=0 ps=0
M1613 DFFNEGX1_64/a_17_6# OAI21X1_93/Y gnd Gnd nfet w=10 l=2
+  ad=0 pd=0 as=0 ps=0
M1614 DFFNEGX1_53/a_76_6# BUFX2_4/Y DFFNEGX1_53/a_66_6# Gnd nfet w=10 l=2
+  ad=29.999998p pd=26u as=80p ps=36u
M1615 gnd BUFX2_4/Y DFFNEGX1_53/a_2_6# Gnd nfet w=20 l=2
+  ad=0 pd=0 as=100p ps=50u
M1616 DFFNEGX1_53/a_66_6# DFFNEGX1_53/a_2_6# DFFNEGX1_53/a_61_6# Gnd nfet w=10 l=2
+  ad=0 pd=0 as=29.999998p ps=26u
M1617 INVX2_84/A DFFNEGX1_53/a_66_6# gnd Gnd nfet w=20 l=2
+  ad=100p pd=50u as=0 ps=0
M1618 DFFNEGX1_53/a_23_6# BUFX2_4/Y DFFNEGX1_53/a_17_6# Gnd nfet w=10 l=2
+  ad=59.999996p pd=32u as=40p ps=28u
M1619 DFFNEGX1_53/a_23_6# DFFNEGX1_53/a_2_6# DFFNEGX1_53/a_17_74# vdd pfet w=20 l=2
+  ad=0.12n pd=52u as=80p ps=48u
M1620 gnd DFFNEGX1_53/a_34_4# DFFNEGX1_53/a_31_6# Gnd nfet w=10 l=2
+  ad=0 pd=0 as=29.999998p ps=26u
M1621 vdd DFFNEGX1_53/a_34_4# DFFNEGX1_53/a_31_74# vdd pfet w=20 l=2
+  ad=0 pd=0 as=80p ps=48u
M1622 DFFNEGX1_53/a_61_74# DFFNEGX1_53/a_34_4# vdd vdd pfet w=20 l=2
+  ad=59.999996p pd=46u as=0 ps=0
M1623 DFFNEGX1_53/a_34_4# DFFNEGX1_53/a_23_6# vdd vdd pfet w=20 l=2
+  ad=100p pd=50u as=0 ps=0
M1624 DFFNEGX1_53/a_34_4# DFFNEGX1_53/a_23_6# gnd Gnd nfet w=10 l=2
+  ad=50p pd=30u as=0 ps=0
M1625 vdd INVX2_84/A DFFNEGX1_53/a_76_84# vdd pfet w=10 l=2
+  ad=0 pd=0 as=29.999998p ps=26u
M1626 gnd INVX2_84/A DFFNEGX1_53/a_76_6# Gnd nfet w=10 l=2
+  ad=0 pd=0 as=0 ps=0
M1627 DFFNEGX1_53/a_61_6# DFFNEGX1_53/a_34_4# gnd Gnd nfet w=10 l=2
+  ad=0 pd=0 as=0 ps=0
M1628 DFFNEGX1_53/a_76_84# DFFNEGX1_53/a_2_6# DFFNEGX1_53/a_66_6# vdd pfet w=10 l=2
+  ad=0 pd=0 as=0.15n ps=56u
M1629 INVX2_84/A DFFNEGX1_53/a_66_6# vdd vdd pfet w=40 l=2
+  ad=0.2n pd=90u as=0 ps=0
M1630 vdd BUFX2_4/Y DFFNEGX1_53/a_2_6# vdd pfet w=40 l=2
+  ad=0 pd=0 as=0.2n ps=90u
M1631 DFFNEGX1_53/a_31_6# DFFNEGX1_53/a_2_6# DFFNEGX1_53/a_23_6# Gnd nfet w=10 l=2
+  ad=0 pd=0 as=0 ps=0
M1632 DFFNEGX1_53/a_66_6# BUFX2_4/Y DFFNEGX1_53/a_61_74# vdd pfet w=20 l=2
+  ad=0 pd=0 as=0 ps=0
M1633 DFFNEGX1_53/a_17_74# OAI21X1_72/Y vdd vdd pfet w=20 l=2
+  ad=0 pd=0 as=0 ps=0
M1634 DFFNEGX1_53/a_31_74# BUFX2_4/Y DFFNEGX1_53/a_23_6# vdd pfet w=20 l=2
+  ad=0 pd=0 as=0 ps=0
M1635 DFFNEGX1_53/a_17_6# OAI21X1_72/Y gnd Gnd nfet w=10 l=2
+  ad=0 pd=0 as=0 ps=0
M1636 AND2X2_7/a_2_6# AND2X2_7/A vdd vdd pfet w=20 l=2
+  ad=0.12n pd=52u as=0 ps=0
M1637 AND2X2_7/a_9_6# AND2X2_7/A AND2X2_7/a_2_6# Gnd nfet w=20 l=2
+  ad=59.999996p pd=46u as=100p ps=50u
M1638 AND2X2_7/Y AND2X2_7/a_2_6# gnd Gnd nfet w=20 l=2
+  ad=100p pd=50u as=0 ps=0
M1639 AND2X2_7/Y AND2X2_7/a_2_6# vdd vdd pfet w=40 l=2
+  ad=0.2n pd=90u as=0 ps=0
M1640 vdd AND2X2_7/B AND2X2_7/a_2_6# vdd pfet w=20 l=2
+  ad=0 pd=0 as=0 ps=0
M1641 gnd AND2X2_7/B AND2X2_7/a_9_6# Gnd nfet w=20 l=2
+  ad=0 pd=0 as=0 ps=0
M1642 gnd INVX2_40/Y AOI22X1_2/a_28_6# Gnd nfet w=20 l=2
+  ad=0 pd=0 as=59.999996p ps=46u
M1643 OR2X1_1/A INVX2_40/Y AOI22X1_2/a_11_6# Gnd nfet w=20 l=2
+  ad=0.2n pd=60u as=59.999996p ps=46u
M1644 AOI22X1_2/a_11_6# AOI22X1_2/A gnd Gnd nfet w=20 l=2
+  ad=0 pd=0 as=0 ps=0
M1645 AOI22X1_2/a_2_54# INVX2_40/Y vdd vdd pfet w=40 l=2
+  ad=0.64n pd=0.272m as=0 ps=0
M1646 AOI22X1_2/a_28_6# OAI21X1_7/Y OR2X1_1/A Gnd nfet w=20 l=2
+  ad=0 pd=0 as=0 ps=0
M1647 vdd AOI22X1_2/A AOI22X1_2/a_2_54# vdd pfet w=40 l=2
+  ad=0 pd=0 as=0 ps=0
M1648 OR2X1_1/A OAI21X1_7/Y AOI22X1_2/a_2_54# vdd pfet w=40 l=2
+  ad=0.24n pd=92u as=0 ps=0
M1649 AOI22X1_2/a_2_54# INVX2_40/Y OR2X1_1/A vdd pfet w=40 l=2
+  ad=0 pd=0 as=0 ps=0
M1650 OAI21X1_1/C player_bullet_coord_x[3] vdd vdd pfet w=20 l=2
+  ad=0.12n pd=52u as=0 ps=0
M1651 NAND2X1_12/a_9_6# player_bullet_coord_x[3] gnd Gnd nfet w=20 l=2
+  ad=59.999996p pd=46u as=0 ps=0
M1652 vdd INVX2_48/Y OAI21X1_1/C vdd pfet w=20 l=2
+  ad=0 pd=0 as=0 ps=0
M1653 OAI21X1_1/C INVX2_48/Y NAND2X1_12/a_9_6# Gnd nfet w=20 l=2
+  ad=100p pd=50u as=0 ps=0
M1654 NAND3X1_8/A INVX2_79/Y vdd vdd pfet w=20 l=2
+  ad=0.12n pd=52u as=0 ps=0
M1655 NAND2X1_23/a_9_6# INVX2_79/Y gnd Gnd nfet w=20 l=2
+  ad=59.999996p pd=46u as=0 ps=0
M1656 vdd INVX2_23/Y NAND3X1_8/A vdd pfet w=20 l=2
+  ad=0 pd=0 as=0 ps=0
M1657 NAND3X1_8/A INVX2_23/Y NAND2X1_23/a_9_6# Gnd nfet w=20 l=2
+  ad=100p pd=50u as=0 ps=0
M1658 OAI21X1_55/C OR2X1_20/B vdd vdd pfet w=20 l=2
+  ad=0.12n pd=52u as=0 ps=0
M1659 NAND2X1_34/a_9_6# OR2X1_20/B gnd Gnd nfet w=20 l=2
+  ad=59.999996p pd=46u as=0 ps=0
M1660 vdd NOR2X1_31/Y OAI21X1_55/C vdd pfet w=20 l=2
+  ad=0 pd=0 as=0 ps=0
M1661 OAI21X1_55/C NOR2X1_31/Y NAND2X1_34/a_9_6# Gnd nfet w=20 l=2
+  ad=100p pd=50u as=0 ps=0
M1662 INVX2_131/A NOR2X1_52/Y vdd vdd pfet w=20 l=2
+  ad=0.12n pd=52u as=0 ps=0
M1663 NAND2X1_56/a_9_6# NOR2X1_52/Y gnd Gnd nfet w=20 l=2
+  ad=59.999996p pd=46u as=0 ps=0
M1664 vdd NAND2X1_1/B INVX2_131/A vdd pfet w=20 l=2
+  ad=0 pd=0 as=0 ps=0
M1665 INVX2_131/A NAND2X1_1/B NAND2X1_56/a_9_6# Gnd nfet w=20 l=2
+  ad=100p pd=50u as=0 ps=0
M1666 OAI21X1_92/C NOR2X1_28/A vdd vdd pfet w=20 l=2
+  ad=0.12n pd=52u as=0 ps=0
M1667 NAND2X1_45/a_9_6# NOR2X1_28/A gnd Gnd nfet w=20 l=2
+  ad=59.999996p pd=46u as=0 ps=0
M1668 vdd AND2X2_17/Y OAI21X1_92/C vdd pfet w=20 l=2
+  ad=0 pd=0 as=0 ps=0
M1669 OAI21X1_92/C AND2X2_17/Y NAND2X1_45/a_9_6# Gnd nfet w=20 l=2
+  ad=100p pd=50u as=0 ps=0
M1670 INVX2_107/A NAND2X1_67/A vdd vdd pfet w=20 l=2
+  ad=0.12n pd=52u as=0 ps=0
M1671 NAND2X1_67/a_9_6# NAND2X1_67/A gnd Gnd nfet w=20 l=2
+  ad=59.999996p pd=46u as=0 ps=0
M1672 vdd invader_2_display INVX2_107/A vdd pfet w=20 l=2
+  ad=0 pd=0 as=0 ps=0
M1673 INVX2_107/A invader_2_display NAND2X1_67/a_9_6# Gnd nfet w=20 l=2
+  ad=100p pd=50u as=0 ps=0
M1674 NAND2X1_78/Y NOR2X1_57/B vdd vdd pfet w=20 l=2
+  ad=0.12n pd=52u as=0 ps=0
M1675 NAND2X1_78/a_9_6# NOR2X1_57/B gnd Gnd nfet w=20 l=2
+  ad=59.999996p pd=46u as=0 ps=0
M1676 vdd NAND2X1_78/B NAND2X1_78/Y vdd pfet w=20 l=2
+  ad=0 pd=0 as=0 ps=0
M1677 NAND2X1_78/Y NAND2X1_78/B NAND2X1_78/a_9_6# Gnd nfet w=20 l=2
+  ad=100p pd=50u as=0 ps=0
M1678 gnd shield_coord_x[1] AOI22X1_10/a_28_6# Gnd nfet w=20 l=2
+  ad=0 pd=0 as=59.999996p ps=46u
M1679 AOI22X1_9/C INVX2_5/Y AOI22X1_10/a_11_6# Gnd nfet w=20 l=2
+  ad=0.2n pd=60u as=59.999996p ps=46u
M1680 AOI22X1_10/a_11_6# shield_coord_x[2] gnd Gnd nfet w=20 l=2
+  ad=0 pd=0 as=0 ps=0
M1681 AOI22X1_10/a_2_54# INVX2_5/Y vdd vdd pfet w=40 l=2
+  ad=0.64n pd=0.272m as=0 ps=0
M1682 AOI22X1_10/a_28_6# invader_bullet_coord_x[1] AOI22X1_9/C Gnd nfet w=20 l=2
+  ad=0 pd=0 as=0 ps=0
M1683 vdd shield_coord_x[2] AOI22X1_10/a_2_54# vdd pfet w=40 l=2
+  ad=0 pd=0 as=0 ps=0
M1684 AOI22X1_9/C invader_bullet_coord_x[1] AOI22X1_10/a_2_54# vdd pfet w=40 l=2
+  ad=0.24n pd=92u as=0 ps=0
M1685 AOI22X1_10/a_2_54# shield_coord_x[1] AOI22X1_9/C vdd pfet w=40 l=2
+  ad=0 pd=0 as=0 ps=0
M1686 gnd player_bullet_coord_x[0] AOI22X1_21/a_28_6# Gnd nfet w=20 l=2
+  ad=0 pd=0 as=59.999996p ps=46u
M1687 INVX2_140/A NOR2X1_26/Y AOI22X1_21/a_11_6# Gnd nfet w=20 l=2
+  ad=0.2n pd=60u as=59.999996p ps=46u
M1688 AOI22X1_21/a_11_6# player_coord_x[0] gnd Gnd nfet w=20 l=2
+  ad=0 pd=0 as=0 ps=0
M1689 AOI22X1_21/a_2_54# NOR2X1_26/Y vdd vdd pfet w=40 l=2
+  ad=0.64n pd=0.272m as=0 ps=0
M1690 AOI22X1_21/a_28_6# AND2X2_0/A INVX2_140/A Gnd nfet w=20 l=2
+  ad=0 pd=0 as=0 ps=0
M1691 vdd player_coord_x[0] AOI22X1_21/a_2_54# vdd pfet w=40 l=2
+  ad=0 pd=0 as=0 ps=0
M1692 INVX2_140/A AND2X2_0/A AOI22X1_21/a_2_54# vdd pfet w=40 l=2
+  ad=0.24n pd=92u as=0 ps=0
M1693 AOI22X1_21/a_2_54# player_bullet_coord_x[0] INVX2_140/A vdd pfet w=40 l=2
+  ad=0 pd=0 as=0 ps=0
M1694 gnd HAX1_9/YS AOI22X1_32/a_28_6# Gnd nfet w=20 l=2
+  ad=0 pd=0 as=59.999996p ps=46u
M1695 OAI21X1_77/C AND2X2_13/Y AOI22X1_32/a_11_6# Gnd nfet w=20 l=2
+  ad=0.2n pd=60u as=59.999996p ps=46u
M1696 AOI22X1_32/a_11_6# INVX2_68/Y gnd Gnd nfet w=20 l=2
+  ad=0 pd=0 as=0 ps=0
M1697 AOI22X1_32/a_2_54# AND2X2_13/Y vdd vdd pfet w=40 l=2
+  ad=0.64n pd=0.272m as=0 ps=0
M1698 AOI22X1_32/a_28_6# AND2X2_12/Y OAI21X1_77/C Gnd nfet w=20 l=2
+  ad=0 pd=0 as=0 ps=0
M1699 vdd INVX2_68/Y AOI22X1_32/a_2_54# vdd pfet w=40 l=2
+  ad=0 pd=0 as=0 ps=0
M1700 OAI21X1_77/C AND2X2_12/Y AOI22X1_32/a_2_54# vdd pfet w=40 l=2
+  ad=0.24n pd=92u as=0 ps=0
M1701 AOI22X1_32/a_2_54# HAX1_9/YS OAI21X1_77/C vdd pfet w=40 l=2
+  ad=0 pd=0 as=0 ps=0
M1702 gnd OR2X1_15/B AOI22X1_43/a_28_6# Gnd nfet w=20 l=2
+  ad=0 pd=0 as=59.999996p ps=46u
M1703 NOR2X1_49/B INVX2_96/A AOI22X1_43/a_11_6# Gnd nfet w=20 l=2
+  ad=0.2n pd=60u as=59.999996p ps=46u
M1704 AOI22X1_43/a_11_6# NOR2X1_50/Y gnd Gnd nfet w=20 l=2
+  ad=0 pd=0 as=0 ps=0
M1705 AOI22X1_43/a_2_54# INVX2_96/A vdd vdd pfet w=40 l=2
+  ad=0.64n pd=0.272m as=0 ps=0
M1706 AOI22X1_43/a_28_6# INVX2_96/Y NOR2X1_49/B Gnd nfet w=20 l=2
+  ad=0 pd=0 as=0 ps=0
M1707 vdd NOR2X1_50/Y AOI22X1_43/a_2_54# vdd pfet w=40 l=2
+  ad=0 pd=0 as=0 ps=0
M1708 NOR2X1_49/B INVX2_96/Y AOI22X1_43/a_2_54# vdd pfet w=40 l=2
+  ad=0.24n pd=92u as=0 ps=0
M1709 AOI22X1_43/a_2_54# OR2X1_15/B NOR2X1_49/B vdd pfet w=40 l=2
+  ad=0 pd=0 as=0 ps=0
M1710 gnd invader_2_coord_y[2] AOI22X1_54/a_28_6# Gnd nfet w=20 l=2
+  ad=0 pd=0 as=59.999996p ps=46u
M1711 OAI21X1_39/B OAI22X1_8/A AOI22X1_54/a_11_6# Gnd nfet w=20 l=2
+  ad=0.2n pd=60u as=59.999996p ps=46u
M1712 AOI22X1_54/a_11_6# invader_1_coord_y[2] gnd Gnd nfet w=20 l=2
+  ad=0 pd=0 as=0 ps=0
M1713 AOI22X1_54/a_2_54# OAI22X1_8/A vdd vdd pfet w=40 l=2
+  ad=0.64n pd=0.272m as=0 ps=0
M1714 AOI22X1_54/a_28_6# OAI22X1_8/D OAI21X1_39/B Gnd nfet w=20 l=2
+  ad=0 pd=0 as=0 ps=0
M1715 vdd invader_1_coord_y[2] AOI22X1_54/a_2_54# vdd pfet w=40 l=2
+  ad=0 pd=0 as=0 ps=0
M1716 OAI21X1_39/B OAI22X1_8/D AOI22X1_54/a_2_54# vdd pfet w=40 l=2
+  ad=0.24n pd=92u as=0 ps=0
M1717 AOI22X1_54/a_2_54# invader_2_coord_y[2] OAI21X1_39/B vdd pfet w=40 l=2
+  ad=0 pd=0 as=0 ps=0
M1718 gnd INVX2_61/Y OAI22X1_5/a_2_6# Gnd nfet w=20 l=2
+  ad=0 pd=0 as=0.32n ps=0.152m
M1719 OAI22X1_5/a_2_6# INVX2_61/A OAI22X1_5/Y Gnd nfet w=20 l=2
+  ad=0 pd=0 as=0.12n ps=52u
M1720 OAI22X1_5/Y OAI22X1_5/D OAI22X1_5/a_2_6# Gnd nfet w=20 l=2
+  ad=0 pd=0 as=0 ps=0
M1721 OAI22X1_5/Y OAI22X1_5/B OAI22X1_5/a_9_54# vdd pfet w=40 l=2
+  ad=0.48n pd=0.104m as=0.12n ps=86u
M1722 OAI22X1_5/a_28_54# OAI22X1_5/D OAI22X1_5/Y vdd pfet w=40 l=2
+  ad=0.12n pd=86u as=0 ps=0
M1723 OAI22X1_5/a_9_54# INVX2_61/Y vdd vdd pfet w=40 l=2
+  ad=0 pd=0 as=0 ps=0
M1724 OAI22X1_5/a_2_6# OAI22X1_5/B gnd Gnd nfet w=20 l=2
+  ad=0 pd=0 as=0 ps=0
M1725 vdd INVX2_61/A OAI22X1_5/a_28_54# vdd pfet w=40 l=2
+  ad=0 pd=0 as=0 ps=0
M1726 INVX2_14/Y player_bullet_coord_y[0] gnd Gnd nfet w=20 l=2
+  ad=100p pd=50u as=0 ps=0
M1727 INVX2_14/Y player_bullet_coord_y[0] vdd vdd pfet w=40 l=2
+  ad=0.2n pd=90u as=0 ps=0
M1728 INVX2_36/Y invader_2_coord_y[2] gnd Gnd nfet w=20 l=2
+  ad=100p pd=50u as=0 ps=0
M1729 INVX2_36/Y invader_2_coord_y[2] vdd vdd pfet w=40 l=2
+  ad=0.2n pd=90u as=0 ps=0
M1730 INVX2_25/Y invader_2_coord_x[0] gnd Gnd nfet w=20 l=2
+  ad=100p pd=50u as=0 ps=0
M1731 INVX2_25/Y invader_2_coord_x[0] vdd vdd pfet w=40 l=2
+  ad=0.2n pd=90u as=0 ps=0
M1732 INVX2_47/Y INVX2_47/A gnd Gnd nfet w=20 l=2
+  ad=100p pd=50u as=0 ps=0
M1733 INVX2_47/Y INVX2_47/A vdd vdd pfet w=40 l=2
+  ad=0.2n pd=90u as=0 ps=0
M1734 INVX2_69/Y INVX2_69/A gnd Gnd nfet w=20 l=2
+  ad=100p pd=50u as=0 ps=0
M1735 INVX2_69/Y INVX2_69/A vdd vdd pfet w=40 l=2
+  ad=0.2n pd=90u as=0 ps=0
M1736 INVX2_58/Y INVX2_58/A gnd Gnd nfet w=20 l=2
+  ad=100p pd=50u as=0 ps=0
M1737 INVX2_58/Y INVX2_58/A vdd vdd pfet w=40 l=2
+  ad=0.2n pd=90u as=0 ps=0
M1738 INVX2_170/Y INVX2_170/A gnd Gnd nfet w=20 l=2
+  ad=100p pd=50u as=0 ps=0
M1739 INVX2_170/Y INVX2_170/A vdd vdd pfet w=40 l=2
+  ad=0.2n pd=90u as=0 ps=0
M1740 OAI22X1_7/B invader_2_coord_x[1] gnd Gnd nfet w=20 l=2
+  ad=100p pd=50u as=0 ps=0
M1741 OAI22X1_7/B invader_2_coord_x[1] vdd vdd pfet w=40 l=2
+  ad=0.2n pd=90u as=0 ps=0
M1742 gnd XNOR2X1_8/A XNOR2X1_8/a_2_6# Gnd nfet w=20 l=2
+  ad=0 pd=0 as=100p ps=50u
M1743 XNOR2X1_8/Y XNOR2X1_8/A XNOR2X1_8/a_18_6# Gnd nfet w=20 l=2
+  ad=0.2n pd=60u as=59.999996p ps=46u
M1744 XNOR2X1_8/a_12_41# XNOR2X1_8/B gnd Gnd nfet w=20 l=2
+  ad=100p pd=50u as=0 ps=0
M1745 XNOR2X1_8/a_18_54# XNOR2X1_8/a_12_41# vdd vdd pfet w=40 l=2
+  ad=0.12n pd=86u as=0 ps=0
M1746 XNOR2X1_8/a_35_6# XNOR2X1_8/a_2_6# XNOR2X1_8/Y Gnd nfet w=20 l=2
+  ad=59.999996p pd=46u as=0 ps=0
M1747 XNOR2X1_8/a_18_6# XNOR2X1_8/a_12_41# gnd Gnd nfet w=20 l=2
+  ad=0 pd=0 as=0 ps=0
M1748 vdd XNOR2X1_8/A XNOR2X1_8/a_2_6# vdd pfet w=40 l=2
+  ad=0 pd=0 as=0.2n ps=90u
M1749 vdd XNOR2X1_8/B XNOR2X1_8/a_35_54# vdd pfet w=40 l=2
+  ad=0 pd=0 as=0.12n ps=86u
M1750 XNOR2X1_8/Y XNOR2X1_8/a_2_6# XNOR2X1_8/a_18_54# vdd pfet w=40 l=2
+  ad=0.4n pd=100u as=0 ps=0
M1751 XNOR2X1_8/a_35_54# XNOR2X1_8/A XNOR2X1_8/Y vdd pfet w=40 l=2
+  ad=0 pd=0 as=0 ps=0
M1752 XNOR2X1_8/a_12_41# XNOR2X1_8/B vdd vdd pfet w=40 l=2
+  ad=0.2n pd=90u as=0 ps=0
M1753 gnd XNOR2X1_8/B XNOR2X1_8/a_35_6# Gnd nfet w=20 l=2
+  ad=0 pd=0 as=0 ps=0
M1754 DFFNEGX1_21/a_76_6# BUFX2_6/Y DFFNEGX1_21/a_66_6# Gnd nfet w=10 l=2
+  ad=29.999998p pd=26u as=80p ps=36u
M1755 gnd BUFX2_6/Y DFFNEGX1_21/a_2_6# Gnd nfet w=20 l=2
+  ad=0 pd=0 as=100p ps=50u
M1756 DFFNEGX1_21/a_66_6# DFFNEGX1_21/a_2_6# DFFNEGX1_21/a_61_6# Gnd nfet w=10 l=2
+  ad=0 pd=0 as=29.999998p ps=26u
M1757 player_bullet_coord_y[3] DFFNEGX1_21/a_66_6# gnd Gnd nfet w=20 l=2
+  ad=100p pd=50u as=0 ps=0
M1758 DFFNEGX1_21/a_23_6# BUFX2_6/Y DFFNEGX1_21/a_17_6# Gnd nfet w=10 l=2
+  ad=59.999996p pd=32u as=40p ps=28u
M1759 DFFNEGX1_21/a_23_6# DFFNEGX1_21/a_2_6# DFFNEGX1_21/a_17_74# vdd pfet w=20 l=2
+  ad=0.12n pd=52u as=80p ps=48u
M1760 gnd DFFNEGX1_21/a_34_4# DFFNEGX1_21/a_31_6# Gnd nfet w=10 l=2
+  ad=0 pd=0 as=29.999998p ps=26u
M1761 vdd DFFNEGX1_21/a_34_4# DFFNEGX1_21/a_31_74# vdd pfet w=20 l=2
+  ad=0 pd=0 as=80p ps=48u
M1762 DFFNEGX1_21/a_61_74# DFFNEGX1_21/a_34_4# vdd vdd pfet w=20 l=2
+  ad=59.999996p pd=46u as=0 ps=0
M1763 DFFNEGX1_21/a_34_4# DFFNEGX1_21/a_23_6# vdd vdd pfet w=20 l=2
+  ad=100p pd=50u as=0 ps=0
M1764 DFFNEGX1_21/a_34_4# DFFNEGX1_21/a_23_6# gnd Gnd nfet w=10 l=2
+  ad=50p pd=30u as=0 ps=0
M1765 vdd player_bullet_coord_y[3] DFFNEGX1_21/a_76_84# vdd pfet w=10 l=2
+  ad=0 pd=0 as=29.999998p ps=26u
M1766 gnd player_bullet_coord_y[3] DFFNEGX1_21/a_76_6# Gnd nfet w=10 l=2
+  ad=0 pd=0 as=0 ps=0
M1767 DFFNEGX1_21/a_61_6# DFFNEGX1_21/a_34_4# gnd Gnd nfet w=10 l=2
+  ad=0 pd=0 as=0 ps=0
M1768 DFFNEGX1_21/a_76_84# DFFNEGX1_21/a_2_6# DFFNEGX1_21/a_66_6# vdd pfet w=10 l=2
+  ad=0 pd=0 as=0.15n ps=56u
M1769 player_bullet_coord_y[3] DFFNEGX1_21/a_66_6# vdd vdd pfet w=40 l=2
+  ad=0.2n pd=90u as=0 ps=0
M1770 vdd BUFX2_6/Y DFFNEGX1_21/a_2_6# vdd pfet w=40 l=2
+  ad=0 pd=0 as=0.2n ps=90u
M1771 DFFNEGX1_21/a_31_6# DFFNEGX1_21/a_2_6# DFFNEGX1_21/a_23_6# Gnd nfet w=10 l=2
+  ad=0 pd=0 as=0 ps=0
M1772 DFFNEGX1_21/a_66_6# BUFX2_6/Y DFFNEGX1_21/a_61_74# vdd pfet w=20 l=2
+  ad=0 pd=0 as=0 ps=0
M1773 DFFNEGX1_21/a_17_74# OAI21X1_47/Y vdd vdd pfet w=20 l=2
+  ad=0 pd=0 as=0 ps=0
M1774 DFFNEGX1_21/a_31_74# BUFX2_6/Y DFFNEGX1_21/a_23_6# vdd pfet w=20 l=2
+  ad=0 pd=0 as=0 ps=0
M1775 DFFNEGX1_21/a_17_6# OAI21X1_47/Y gnd Gnd nfet w=10 l=2
+  ad=0 pd=0 as=0 ps=0
M1776 DFFNEGX1_10/a_76_6# BUFX2_7/Y DFFNEGX1_10/a_66_6# Gnd nfet w=10 l=2
+  ad=29.999998p pd=26u as=80p ps=36u
M1777 gnd BUFX2_7/Y DFFNEGX1_10/a_2_6# Gnd nfet w=20 l=2
+  ad=0 pd=0 as=100p ps=50u
M1778 DFFNEGX1_10/a_66_6# DFFNEGX1_10/a_2_6# DFFNEGX1_10/a_61_6# Gnd nfet w=10 l=2
+  ad=0 pd=0 as=29.999998p ps=26u
M1779 invader_bullet_coord_y[2] DFFNEGX1_10/a_66_6# gnd Gnd nfet w=20 l=2
+  ad=100p pd=50u as=0 ps=0
M1780 DFFNEGX1_10/a_23_6# BUFX2_7/Y DFFNEGX1_10/a_17_6# Gnd nfet w=10 l=2
+  ad=59.999996p pd=32u as=40p ps=28u
M1781 DFFNEGX1_10/a_23_6# DFFNEGX1_10/a_2_6# DFFNEGX1_10/a_17_74# vdd pfet w=20 l=2
+  ad=0.12n pd=52u as=80p ps=48u
M1782 gnd DFFNEGX1_10/a_34_4# DFFNEGX1_10/a_31_6# Gnd nfet w=10 l=2
+  ad=0 pd=0 as=29.999998p ps=26u
M1783 vdd DFFNEGX1_10/a_34_4# DFFNEGX1_10/a_31_74# vdd pfet w=20 l=2
+  ad=0 pd=0 as=80p ps=48u
M1784 DFFNEGX1_10/a_61_74# DFFNEGX1_10/a_34_4# vdd vdd pfet w=20 l=2
+  ad=59.999996p pd=46u as=0 ps=0
M1785 DFFNEGX1_10/a_34_4# DFFNEGX1_10/a_23_6# vdd vdd pfet w=20 l=2
+  ad=100p pd=50u as=0 ps=0
M1786 DFFNEGX1_10/a_34_4# DFFNEGX1_10/a_23_6# gnd Gnd nfet w=10 l=2
+  ad=50p pd=30u as=0 ps=0
M1787 vdd invader_bullet_coord_y[2] DFFNEGX1_10/a_76_84# vdd pfet w=10 l=2
+  ad=0 pd=0 as=29.999998p ps=26u
M1788 gnd invader_bullet_coord_y[2] DFFNEGX1_10/a_76_6# Gnd nfet w=10 l=2
+  ad=0 pd=0 as=0 ps=0
M1789 DFFNEGX1_10/a_61_6# DFFNEGX1_10/a_34_4# gnd Gnd nfet w=10 l=2
+  ad=0 pd=0 as=0 ps=0
M1790 DFFNEGX1_10/a_76_84# DFFNEGX1_10/a_2_6# DFFNEGX1_10/a_66_6# vdd pfet w=10 l=2
+  ad=0 pd=0 as=0.15n ps=56u
M1791 invader_bullet_coord_y[2] DFFNEGX1_10/a_66_6# vdd vdd pfet w=40 l=2
+  ad=0.2n pd=90u as=0 ps=0
M1792 vdd BUFX2_7/Y DFFNEGX1_10/a_2_6# vdd pfet w=40 l=2
+  ad=0 pd=0 as=0.2n ps=90u
M1793 DFFNEGX1_10/a_31_6# DFFNEGX1_10/a_2_6# DFFNEGX1_10/a_23_6# Gnd nfet w=10 l=2
+  ad=0 pd=0 as=0 ps=0
M1794 DFFNEGX1_10/a_66_6# BUFX2_7/Y DFFNEGX1_10/a_61_74# vdd pfet w=20 l=2
+  ad=0 pd=0 as=0 ps=0
M1795 DFFNEGX1_10/a_17_74# INVX2_143/Y vdd vdd pfet w=20 l=2
+  ad=0 pd=0 as=0 ps=0
M1796 DFFNEGX1_10/a_31_74# BUFX2_7/Y DFFNEGX1_10/a_23_6# vdd pfet w=20 l=2
+  ad=0 pd=0 as=0 ps=0
M1797 DFFNEGX1_10/a_17_6# INVX2_143/Y gnd Gnd nfet w=10 l=2
+  ad=0 pd=0 as=0 ps=0
M1798 DFFNEGX1_32/a_76_6# BUFX2_5/Y DFFNEGX1_32/a_66_6# Gnd nfet w=10 l=2
+  ad=29.999998p pd=26u as=80p ps=36u
M1799 gnd BUFX2_5/Y DFFNEGX1_32/a_2_6# Gnd nfet w=20 l=2
+  ad=0 pd=0 as=100p ps=50u
M1800 DFFNEGX1_32/a_66_6# DFFNEGX1_32/a_2_6# DFFNEGX1_32/a_61_6# Gnd nfet w=10 l=2
+  ad=0 pd=0 as=29.999998p ps=26u
M1801 invader_2_coord_y[2] DFFNEGX1_32/a_66_6# gnd Gnd nfet w=20 l=2
+  ad=100p pd=50u as=0 ps=0
M1802 DFFNEGX1_32/a_23_6# BUFX2_5/Y DFFNEGX1_32/a_17_6# Gnd nfet w=10 l=2
+  ad=59.999996p pd=32u as=40p ps=28u
M1803 DFFNEGX1_32/a_23_6# DFFNEGX1_32/a_2_6# DFFNEGX1_32/a_17_74# vdd pfet w=20 l=2
+  ad=0.12n pd=52u as=80p ps=48u
M1804 gnd DFFNEGX1_32/a_34_4# DFFNEGX1_32/a_31_6# Gnd nfet w=10 l=2
+  ad=0 pd=0 as=29.999998p ps=26u
M1805 vdd DFFNEGX1_32/a_34_4# DFFNEGX1_32/a_31_74# vdd pfet w=20 l=2
+  ad=0 pd=0 as=80p ps=48u
M1806 DFFNEGX1_32/a_61_74# DFFNEGX1_32/a_34_4# vdd vdd pfet w=20 l=2
+  ad=59.999996p pd=46u as=0 ps=0
M1807 DFFNEGX1_32/a_34_4# DFFNEGX1_32/a_23_6# vdd vdd pfet w=20 l=2
+  ad=100p pd=50u as=0 ps=0
M1808 DFFNEGX1_32/a_34_4# DFFNEGX1_32/a_23_6# gnd Gnd nfet w=10 l=2
+  ad=50p pd=30u as=0 ps=0
M1809 vdd invader_2_coord_y[2] DFFNEGX1_32/a_76_84# vdd pfet w=10 l=2
+  ad=0 pd=0 as=29.999998p ps=26u
M1810 gnd invader_2_coord_y[2] DFFNEGX1_32/a_76_6# Gnd nfet w=10 l=2
+  ad=0 pd=0 as=0 ps=0
M1811 DFFNEGX1_32/a_61_6# DFFNEGX1_32/a_34_4# gnd Gnd nfet w=10 l=2
+  ad=0 pd=0 as=0 ps=0
M1812 DFFNEGX1_32/a_76_84# DFFNEGX1_32/a_2_6# DFFNEGX1_32/a_66_6# vdd pfet w=10 l=2
+  ad=0 pd=0 as=0.15n ps=56u
M1813 invader_2_coord_y[2] DFFNEGX1_32/a_66_6# vdd vdd pfet w=40 l=2
+  ad=0.2n pd=90u as=0 ps=0
M1814 vdd BUFX2_5/Y DFFNEGX1_32/a_2_6# vdd pfet w=40 l=2
+  ad=0 pd=0 as=0.2n ps=90u
M1815 DFFNEGX1_32/a_31_6# DFFNEGX1_32/a_2_6# DFFNEGX1_32/a_23_6# Gnd nfet w=10 l=2
+  ad=0 pd=0 as=0 ps=0
M1816 DFFNEGX1_32/a_66_6# BUFX2_5/Y DFFNEGX1_32/a_61_74# vdd pfet w=20 l=2
+  ad=0 pd=0 as=0 ps=0
M1817 DFFNEGX1_32/a_17_74# OR2X1_7/Y vdd vdd pfet w=20 l=2
+  ad=0 pd=0 as=0 ps=0
M1818 DFFNEGX1_32/a_31_74# BUFX2_5/Y DFFNEGX1_32/a_23_6# vdd pfet w=20 l=2
+  ad=0 pd=0 as=0 ps=0
M1819 DFFNEGX1_32/a_17_6# OR2X1_7/Y gnd Gnd nfet w=10 l=2
+  ad=0 pd=0 as=0 ps=0
M1820 DFFNEGX1_43/a_76_6# clka DFFNEGX1_43/a_66_6# Gnd nfet w=10 l=2
+  ad=29.999998p pd=26u as=80p ps=36u
M1821 gnd clka DFFNEGX1_43/a_2_6# Gnd nfet w=20 l=2
+  ad=0 pd=0 as=100p ps=50u
M1822 DFFNEGX1_43/a_66_6# DFFNEGX1_43/a_2_6# DFFNEGX1_43/a_61_6# Gnd nfet w=10 l=2
+  ad=0 pd=0 as=29.999998p ps=26u
M1823 NOR2X1_35/B DFFNEGX1_43/a_66_6# gnd Gnd nfet w=20 l=2
+  ad=100p pd=50u as=0 ps=0
M1824 DFFNEGX1_43/a_23_6# clka DFFNEGX1_43/a_17_6# Gnd nfet w=10 l=2
+  ad=59.999996p pd=32u as=40p ps=28u
M1825 DFFNEGX1_43/a_23_6# DFFNEGX1_43/a_2_6# DFFNEGX1_43/a_17_74# vdd pfet w=20 l=2
+  ad=0.12n pd=52u as=80p ps=48u
M1826 gnd DFFNEGX1_43/a_34_4# DFFNEGX1_43/a_31_6# Gnd nfet w=10 l=2
+  ad=0 pd=0 as=29.999998p ps=26u
M1827 vdd DFFNEGX1_43/a_34_4# DFFNEGX1_43/a_31_74# vdd pfet w=20 l=2
+  ad=0 pd=0 as=80p ps=48u
M1828 DFFNEGX1_43/a_61_74# DFFNEGX1_43/a_34_4# vdd vdd pfet w=20 l=2
+  ad=59.999996p pd=46u as=0 ps=0
M1829 DFFNEGX1_43/a_34_4# DFFNEGX1_43/a_23_6# vdd vdd pfet w=20 l=2
+  ad=100p pd=50u as=0 ps=0
M1830 DFFNEGX1_43/a_34_4# DFFNEGX1_43/a_23_6# gnd Gnd nfet w=10 l=2
+  ad=50p pd=30u as=0 ps=0
M1831 vdd NOR2X1_35/B DFFNEGX1_43/a_76_84# vdd pfet w=10 l=2
+  ad=0 pd=0 as=29.999998p ps=26u
M1832 gnd NOR2X1_35/B DFFNEGX1_43/a_76_6# Gnd nfet w=10 l=2
+  ad=0 pd=0 as=0 ps=0
M1833 DFFNEGX1_43/a_61_6# DFFNEGX1_43/a_34_4# gnd Gnd nfet w=10 l=2
+  ad=0 pd=0 as=0 ps=0
M1834 DFFNEGX1_43/a_76_84# DFFNEGX1_43/a_2_6# DFFNEGX1_43/a_66_6# vdd pfet w=10 l=2
+  ad=0 pd=0 as=0.15n ps=56u
M1835 NOR2X1_35/B DFFNEGX1_43/a_66_6# vdd vdd pfet w=40 l=2
+  ad=0.2n pd=90u as=0 ps=0
M1836 vdd clka DFFNEGX1_43/a_2_6# vdd pfet w=40 l=2
+  ad=0 pd=0 as=0.2n ps=90u
M1837 DFFNEGX1_43/a_31_6# DFFNEGX1_43/a_2_6# DFFNEGX1_43/a_23_6# Gnd nfet w=10 l=2
+  ad=0 pd=0 as=0 ps=0
M1838 DFFNEGX1_43/a_66_6# clka DFFNEGX1_43/a_61_74# vdd pfet w=20 l=2
+  ad=0 pd=0 as=0 ps=0
M1839 DFFNEGX1_43/a_17_74# OAI21X1_90/Y vdd vdd pfet w=20 l=2
+  ad=0 pd=0 as=0 ps=0
M1840 DFFNEGX1_43/a_31_74# clka DFFNEGX1_43/a_23_6# vdd pfet w=20 l=2
+  ad=0 pd=0 as=0 ps=0
M1841 DFFNEGX1_43/a_17_6# OAI21X1_90/Y gnd Gnd nfet w=10 l=2
+  ad=0 pd=0 as=0 ps=0
M1842 DFFNEGX1_54/a_76_6# BUFX2_4/Y DFFNEGX1_54/a_66_6# Gnd nfet w=10 l=2
+  ad=29.999998p pd=26u as=80p ps=36u
M1843 gnd BUFX2_4/Y DFFNEGX1_54/a_2_6# Gnd nfet w=20 l=2
+  ad=0 pd=0 as=100p ps=50u
M1844 DFFNEGX1_54/a_66_6# DFFNEGX1_54/a_2_6# DFFNEGX1_54/a_61_6# Gnd nfet w=10 l=2
+  ad=0 pd=0 as=29.999998p ps=26u
M1845 shield_hp[0] DFFNEGX1_54/a_66_6# gnd Gnd nfet w=20 l=2
+  ad=100p pd=50u as=0 ps=0
M1846 DFFNEGX1_54/a_23_6# BUFX2_4/Y DFFNEGX1_54/a_17_6# Gnd nfet w=10 l=2
+  ad=59.999996p pd=32u as=40p ps=28u
M1847 DFFNEGX1_54/a_23_6# DFFNEGX1_54/a_2_6# DFFNEGX1_54/a_17_74# vdd pfet w=20 l=2
+  ad=0.12n pd=52u as=80p ps=48u
M1848 gnd DFFNEGX1_54/a_34_4# DFFNEGX1_54/a_31_6# Gnd nfet w=10 l=2
+  ad=0 pd=0 as=29.999998p ps=26u
M1849 vdd DFFNEGX1_54/a_34_4# DFFNEGX1_54/a_31_74# vdd pfet w=20 l=2
+  ad=0 pd=0 as=80p ps=48u
M1850 DFFNEGX1_54/a_61_74# DFFNEGX1_54/a_34_4# vdd vdd pfet w=20 l=2
+  ad=59.999996p pd=46u as=0 ps=0
M1851 DFFNEGX1_54/a_34_4# DFFNEGX1_54/a_23_6# vdd vdd pfet w=20 l=2
+  ad=100p pd=50u as=0 ps=0
M1852 DFFNEGX1_54/a_34_4# DFFNEGX1_54/a_23_6# gnd Gnd nfet w=10 l=2
+  ad=50p pd=30u as=0 ps=0
M1853 vdd shield_hp[0] DFFNEGX1_54/a_76_84# vdd pfet w=10 l=2
+  ad=0 pd=0 as=29.999998p ps=26u
M1854 gnd shield_hp[0] DFFNEGX1_54/a_76_6# Gnd nfet w=10 l=2
+  ad=0 pd=0 as=0 ps=0
M1855 DFFNEGX1_54/a_61_6# DFFNEGX1_54/a_34_4# gnd Gnd nfet w=10 l=2
+  ad=0 pd=0 as=0 ps=0
M1856 DFFNEGX1_54/a_76_84# DFFNEGX1_54/a_2_6# DFFNEGX1_54/a_66_6# vdd pfet w=10 l=2
+  ad=0 pd=0 as=0.15n ps=56u
M1857 shield_hp[0] DFFNEGX1_54/a_66_6# vdd vdd pfet w=40 l=2
+  ad=0.2n pd=90u as=0 ps=0
M1858 vdd BUFX2_4/Y DFFNEGX1_54/a_2_6# vdd pfet w=40 l=2
+  ad=0 pd=0 as=0.2n ps=90u
M1859 DFFNEGX1_54/a_31_6# DFFNEGX1_54/a_2_6# DFFNEGX1_54/a_23_6# Gnd nfet w=10 l=2
+  ad=0 pd=0 as=0 ps=0
M1860 DFFNEGX1_54/a_66_6# BUFX2_4/Y DFFNEGX1_54/a_61_74# vdd pfet w=20 l=2
+  ad=0 pd=0 as=0 ps=0
M1861 DFFNEGX1_54/a_17_74# OR2X1_11/Y vdd vdd pfet w=20 l=2
+  ad=0 pd=0 as=0 ps=0
M1862 DFFNEGX1_54/a_31_74# BUFX2_4/Y DFFNEGX1_54/a_23_6# vdd pfet w=20 l=2
+  ad=0 pd=0 as=0 ps=0
M1863 DFFNEGX1_54/a_17_6# OR2X1_11/Y gnd Gnd nfet w=10 l=2
+  ad=0 pd=0 as=0 ps=0
M1864 DFFNEGX1_76/a_76_6# BUFX2_2/Y DFFNEGX1_76/a_66_6# Gnd nfet w=10 l=2
+  ad=29.999998p pd=26u as=80p ps=36u
M1865 gnd BUFX2_2/Y DFFNEGX1_76/a_2_6# Gnd nfet w=20 l=2
+  ad=0 pd=0 as=100p ps=50u
M1866 DFFNEGX1_76/a_66_6# DFFNEGX1_76/a_2_6# DFFNEGX1_76/a_61_6# Gnd nfet w=10 l=2
+  ad=0 pd=0 as=29.999998p ps=26u
M1867 INVX2_124/A DFFNEGX1_76/a_66_6# gnd Gnd nfet w=20 l=2
+  ad=100p pd=50u as=0 ps=0
M1868 DFFNEGX1_76/a_23_6# BUFX2_2/Y DFFNEGX1_76/a_17_6# Gnd nfet w=10 l=2
+  ad=59.999996p pd=32u as=40p ps=28u
M1869 DFFNEGX1_76/a_23_6# DFFNEGX1_76/a_2_6# DFFNEGX1_76/a_17_74# vdd pfet w=20 l=2
+  ad=0.12n pd=52u as=80p ps=48u
M1870 gnd DFFNEGX1_76/a_34_4# DFFNEGX1_76/a_31_6# Gnd nfet w=10 l=2
+  ad=0 pd=0 as=29.999998p ps=26u
M1871 vdd DFFNEGX1_76/a_34_4# DFFNEGX1_76/a_31_74# vdd pfet w=20 l=2
+  ad=0 pd=0 as=80p ps=48u
M1872 DFFNEGX1_76/a_61_74# DFFNEGX1_76/a_34_4# vdd vdd pfet w=20 l=2
+  ad=59.999996p pd=46u as=0 ps=0
M1873 DFFNEGX1_76/a_34_4# DFFNEGX1_76/a_23_6# vdd vdd pfet w=20 l=2
+  ad=100p pd=50u as=0 ps=0
M1874 DFFNEGX1_76/a_34_4# DFFNEGX1_76/a_23_6# gnd Gnd nfet w=10 l=2
+  ad=50p pd=30u as=0 ps=0
M1875 vdd INVX2_124/A DFFNEGX1_76/a_76_84# vdd pfet w=10 l=2
+  ad=0 pd=0 as=29.999998p ps=26u
M1876 gnd INVX2_124/A DFFNEGX1_76/a_76_6# Gnd nfet w=10 l=2
+  ad=0 pd=0 as=0 ps=0
M1877 DFFNEGX1_76/a_61_6# DFFNEGX1_76/a_34_4# gnd Gnd nfet w=10 l=2
+  ad=0 pd=0 as=0 ps=0
M1878 DFFNEGX1_76/a_76_84# DFFNEGX1_76/a_2_6# DFFNEGX1_76/a_66_6# vdd pfet w=10 l=2
+  ad=0 pd=0 as=0.15n ps=56u
M1879 INVX2_124/A DFFNEGX1_76/a_66_6# vdd vdd pfet w=40 l=2
+  ad=0.2n pd=90u as=0 ps=0
M1880 vdd BUFX2_2/Y DFFNEGX1_76/a_2_6# vdd pfet w=40 l=2
+  ad=0 pd=0 as=0.2n ps=90u
M1881 DFFNEGX1_76/a_31_6# DFFNEGX1_76/a_2_6# DFFNEGX1_76/a_23_6# Gnd nfet w=10 l=2
+  ad=0 pd=0 as=0 ps=0
M1882 DFFNEGX1_76/a_66_6# BUFX2_2/Y DFFNEGX1_76/a_61_74# vdd pfet w=20 l=2
+  ad=0 pd=0 as=0 ps=0
M1883 DFFNEGX1_76/a_17_74# NOR2X1_60/Y vdd vdd pfet w=20 l=2
+  ad=0 pd=0 as=0 ps=0
M1884 DFFNEGX1_76/a_31_74# BUFX2_2/Y DFFNEGX1_76/a_23_6# vdd pfet w=20 l=2
+  ad=0 pd=0 as=0 ps=0
M1885 DFFNEGX1_76/a_17_6# NOR2X1_60/Y gnd Gnd nfet w=10 l=2
+  ad=0 pd=0 as=0 ps=0
M1886 DFFNEGX1_65/a_76_6# BUFX2_3/Y DFFNEGX1_65/a_66_6# Gnd nfet w=10 l=2
+  ad=29.999998p pd=26u as=80p ps=36u
M1887 gnd BUFX2_3/Y DFFNEGX1_65/a_2_6# Gnd nfet w=20 l=2
+  ad=0 pd=0 as=100p ps=50u
M1888 DFFNEGX1_65/a_66_6# DFFNEGX1_65/a_2_6# DFFNEGX1_65/a_61_6# Gnd nfet w=10 l=2
+  ad=0 pd=0 as=29.999998p ps=26u
M1889 NOR2X1_28/A DFFNEGX1_65/a_66_6# gnd Gnd nfet w=20 l=2
+  ad=100p pd=50u as=0 ps=0
M1890 DFFNEGX1_65/a_23_6# BUFX2_3/Y DFFNEGX1_65/a_17_6# Gnd nfet w=10 l=2
+  ad=59.999996p pd=32u as=40p ps=28u
M1891 DFFNEGX1_65/a_23_6# DFFNEGX1_65/a_2_6# DFFNEGX1_65/a_17_74# vdd pfet w=20 l=2
+  ad=0.12n pd=52u as=80p ps=48u
M1892 gnd DFFNEGX1_65/a_34_4# DFFNEGX1_65/a_31_6# Gnd nfet w=10 l=2
+  ad=0 pd=0 as=29.999998p ps=26u
M1893 vdd DFFNEGX1_65/a_34_4# DFFNEGX1_65/a_31_74# vdd pfet w=20 l=2
+  ad=0 pd=0 as=80p ps=48u
M1894 DFFNEGX1_65/a_61_74# DFFNEGX1_65/a_34_4# vdd vdd pfet w=20 l=2
+  ad=59.999996p pd=46u as=0 ps=0
M1895 DFFNEGX1_65/a_34_4# DFFNEGX1_65/a_23_6# vdd vdd pfet w=20 l=2
+  ad=100p pd=50u as=0 ps=0
M1896 DFFNEGX1_65/a_34_4# DFFNEGX1_65/a_23_6# gnd Gnd nfet w=10 l=2
+  ad=50p pd=30u as=0 ps=0
M1897 vdd NOR2X1_28/A DFFNEGX1_65/a_76_84# vdd pfet w=10 l=2
+  ad=0 pd=0 as=29.999998p ps=26u
M1898 gnd NOR2X1_28/A DFFNEGX1_65/a_76_6# Gnd nfet w=10 l=2
+  ad=0 pd=0 as=0 ps=0
M1899 DFFNEGX1_65/a_61_6# DFFNEGX1_65/a_34_4# gnd Gnd nfet w=10 l=2
+  ad=0 pd=0 as=0 ps=0
M1900 DFFNEGX1_65/a_76_84# DFFNEGX1_65/a_2_6# DFFNEGX1_65/a_66_6# vdd pfet w=10 l=2
+  ad=0 pd=0 as=0.15n ps=56u
M1901 NOR2X1_28/A DFFNEGX1_65/a_66_6# vdd vdd pfet w=40 l=2
+  ad=0.2n pd=90u as=0 ps=0
M1902 vdd BUFX2_3/Y DFFNEGX1_65/a_2_6# vdd pfet w=40 l=2
+  ad=0 pd=0 as=0.2n ps=90u
M1903 DFFNEGX1_65/a_31_6# DFFNEGX1_65/a_2_6# DFFNEGX1_65/a_23_6# Gnd nfet w=10 l=2
+  ad=0 pd=0 as=0 ps=0
M1904 DFFNEGX1_65/a_66_6# BUFX2_3/Y DFFNEGX1_65/a_61_74# vdd pfet w=20 l=2
+  ad=0 pd=0 as=0 ps=0
M1905 DFFNEGX1_65/a_17_74# OAI21X1_92/Y vdd vdd pfet w=20 l=2
+  ad=0 pd=0 as=0 ps=0
M1906 DFFNEGX1_65/a_31_74# BUFX2_3/Y DFFNEGX1_65/a_23_6# vdd pfet w=20 l=2
+  ad=0 pd=0 as=0 ps=0
M1907 DFFNEGX1_65/a_17_6# OAI21X1_92/Y gnd Gnd nfet w=10 l=2
+  ad=0 pd=0 as=0 ps=0
M1908 DFFNEGX1_87/a_76_6# clka DFFNEGX1_87/a_66_6# Gnd nfet w=10 l=2
+  ad=29.999998p pd=26u as=80p ps=36u
M1909 gnd clka DFFNEGX1_87/a_2_6# Gnd nfet w=20 l=2
+  ad=0 pd=0 as=100p ps=50u
M1910 DFFNEGX1_87/a_66_6# DFFNEGX1_87/a_2_6# DFFNEGX1_87/a_61_6# Gnd nfet w=10 l=2
+  ad=0 pd=0 as=29.999998p ps=26u
M1911 AOI22X1_47/A DFFNEGX1_87/a_66_6# gnd Gnd nfet w=20 l=2
+  ad=100p pd=50u as=0 ps=0
M1912 DFFNEGX1_87/a_23_6# clka DFFNEGX1_87/a_17_6# Gnd nfet w=10 l=2
+  ad=59.999996p pd=32u as=40p ps=28u
M1913 DFFNEGX1_87/a_23_6# DFFNEGX1_87/a_2_6# DFFNEGX1_87/a_17_74# vdd pfet w=20 l=2
+  ad=0.12n pd=52u as=80p ps=48u
M1914 gnd DFFNEGX1_87/a_34_4# DFFNEGX1_87/a_31_6# Gnd nfet w=10 l=2
+  ad=0 pd=0 as=29.999998p ps=26u
M1915 vdd DFFNEGX1_87/a_34_4# DFFNEGX1_87/a_31_74# vdd pfet w=20 l=2
+  ad=0 pd=0 as=80p ps=48u
M1916 DFFNEGX1_87/a_61_74# DFFNEGX1_87/a_34_4# vdd vdd pfet w=20 l=2
+  ad=59.999996p pd=46u as=0 ps=0
M1917 DFFNEGX1_87/a_34_4# DFFNEGX1_87/a_23_6# vdd vdd pfet w=20 l=2
+  ad=100p pd=50u as=0 ps=0
M1918 DFFNEGX1_87/a_34_4# DFFNEGX1_87/a_23_6# gnd Gnd nfet w=10 l=2
+  ad=50p pd=30u as=0 ps=0
M1919 vdd AOI22X1_47/A DFFNEGX1_87/a_76_84# vdd pfet w=10 l=2
+  ad=0 pd=0 as=29.999998p ps=26u
M1920 gnd AOI22X1_47/A DFFNEGX1_87/a_76_6# Gnd nfet w=10 l=2
+  ad=0 pd=0 as=0 ps=0
M1921 DFFNEGX1_87/a_61_6# DFFNEGX1_87/a_34_4# gnd Gnd nfet w=10 l=2
+  ad=0 pd=0 as=0 ps=0
M1922 DFFNEGX1_87/a_76_84# DFFNEGX1_87/a_2_6# DFFNEGX1_87/a_66_6# vdd pfet w=10 l=2
+  ad=0 pd=0 as=0.15n ps=56u
M1923 AOI22X1_47/A DFFNEGX1_87/a_66_6# vdd vdd pfet w=40 l=2
+  ad=0.2n pd=90u as=0 ps=0
M1924 vdd clka DFFNEGX1_87/a_2_6# vdd pfet w=40 l=2
+  ad=0 pd=0 as=0.2n ps=90u
M1925 DFFNEGX1_87/a_31_6# DFFNEGX1_87/a_2_6# DFFNEGX1_87/a_23_6# Gnd nfet w=10 l=2
+  ad=0 pd=0 as=0 ps=0
M1926 DFFNEGX1_87/a_66_6# clka DFFNEGX1_87/a_61_74# vdd pfet w=20 l=2
+  ad=0 pd=0 as=0 ps=0
M1927 DFFNEGX1_87/a_17_74# AND2X2_21/Y vdd vdd pfet w=20 l=2
+  ad=0 pd=0 as=0 ps=0
M1928 DFFNEGX1_87/a_31_74# clka DFFNEGX1_87/a_23_6# vdd pfet w=20 l=2
+  ad=0 pd=0 as=0 ps=0
M1929 DFFNEGX1_87/a_17_6# AND2X2_21/Y gnd Gnd nfet w=10 l=2
+  ad=0 pd=0 as=0 ps=0
M1930 AND2X2_8/a_2_6# AND2X2_8/A vdd vdd pfet w=20 l=2
+  ad=0.12n pd=52u as=0 ps=0
M1931 AND2X2_8/a_9_6# AND2X2_8/A AND2X2_8/a_2_6# Gnd nfet w=20 l=2
+  ad=59.999996p pd=46u as=100p ps=50u
M1932 AND2X2_8/Y AND2X2_8/a_2_6# gnd Gnd nfet w=20 l=2
+  ad=100p pd=50u as=0 ps=0
M1933 AND2X2_8/Y AND2X2_8/a_2_6# vdd vdd pfet w=40 l=2
+  ad=0.2n pd=90u as=0 ps=0
M1934 vdd AND2X2_9/A AND2X2_8/a_2_6# vdd pfet w=20 l=2
+  ad=0 pd=0 as=0 ps=0
M1935 gnd AND2X2_9/A AND2X2_8/a_9_6# Gnd nfet w=20 l=2
+  ad=0 pd=0 as=0 ps=0
M1936 gnd player_bullet_coord_y[1] AOI22X1_3/a_28_6# Gnd nfet w=20 l=2
+  ad=0 pd=0 as=59.999996p ps=46u
M1937 AOI22X1_3/Y invader_2_coord_y[0] AOI22X1_3/a_11_6# Gnd nfet w=20 l=2
+  ad=0.2n pd=60u as=59.999996p ps=46u
M1938 AOI22X1_3/a_11_6# player_bullet_coord_y[0] gnd Gnd nfet w=20 l=2
+  ad=0 pd=0 as=0 ps=0
M1939 AOI22X1_3/a_2_54# invader_2_coord_y[0] vdd vdd pfet w=40 l=2
+  ad=0.64n pd=0.272m as=0 ps=0
M1940 AOI22X1_3/a_28_6# INVX2_34/Y AOI22X1_3/Y Gnd nfet w=20 l=2
+  ad=0 pd=0 as=0 ps=0
M1941 vdd player_bullet_coord_y[0] AOI22X1_3/a_2_54# vdd pfet w=40 l=2
+  ad=0 pd=0 as=0 ps=0
M1942 AOI22X1_3/Y INVX2_34/Y AOI22X1_3/a_2_54# vdd pfet w=40 l=2
+  ad=0.24n pd=92u as=0 ps=0
M1943 AOI22X1_3/a_2_54# player_bullet_coord_y[1] AOI22X1_3/Y vdd pfet w=40 l=2
+  ad=0 pd=0 as=0 ps=0
M1944 NAND2X1_24/Y NAND2X1_30/Y vdd vdd pfet w=20 l=2
+  ad=0.12n pd=52u as=0 ps=0
M1945 NAND2X1_24/a_9_6# NAND2X1_30/Y gnd Gnd nfet w=20 l=2
+  ad=59.999996p pd=46u as=0 ps=0
M1946 vdd NAND3X1_9/Y NAND2X1_24/Y vdd pfet w=20 l=2
+  ad=0 pd=0 as=0 ps=0
M1947 NAND2X1_24/Y NAND3X1_9/Y NAND2X1_24/a_9_6# Gnd nfet w=20 l=2
+  ad=100p pd=50u as=0 ps=0
M1948 OAI21X1_5/C INVX2_50/Y vdd vdd pfet w=20 l=2
+  ad=0.12n pd=52u as=0 ps=0
M1949 NAND2X1_13/a_9_6# INVX2_50/Y gnd Gnd nfet w=20 l=2
+  ad=59.999996p pd=46u as=0 ps=0
M1950 vdd INVX2_18/Y OAI21X1_5/C vdd pfet w=20 l=2
+  ad=0 pd=0 as=0 ps=0
M1951 OAI21X1_5/C INVX2_18/Y NAND2X1_13/a_9_6# Gnd nfet w=20 l=2
+  ad=100p pd=50u as=0 ps=0
M1952 OAI21X1_93/C NOR2X1_20/A vdd vdd pfet w=20 l=2
+  ad=0.12n pd=52u as=0 ps=0
M1953 NAND2X1_46/a_9_6# NOR2X1_20/A gnd Gnd nfet w=20 l=2
+  ad=59.999996p pd=46u as=0 ps=0
M1954 vdd AND2X2_17/Y OAI21X1_93/C vdd pfet w=20 l=2
+  ad=0 pd=0 as=0 ps=0
M1955 OAI21X1_93/C AND2X2_17/Y NAND2X1_46/a_9_6# Gnd nfet w=20 l=2
+  ad=100p pd=50u as=0 ps=0
M1956 NAND2X1_57/Y XNOR2X1_4/Y vdd vdd pfet w=20 l=2
+  ad=0.12n pd=52u as=0 ps=0
M1957 NAND2X1_57/a_9_6# XNOR2X1_4/Y gnd Gnd nfet w=20 l=2
+  ad=59.999996p pd=46u as=0 ps=0
M1958 vdd NAND2X1_57/B NAND2X1_57/Y vdd pfet w=20 l=2
+  ad=0 pd=0 as=0 ps=0
M1959 NAND2X1_57/Y NAND2X1_57/B NAND2X1_57/a_9_6# Gnd nfet w=20 l=2
+  ad=100p pd=50u as=0 ps=0
M1960 OAI21X1_58/C OAI21X1_59/Y vdd vdd pfet w=20 l=2
+  ad=0.12n pd=52u as=0 ps=0
M1961 NAND2X1_35/a_9_6# OAI21X1_59/Y gnd Gnd nfet w=20 l=2
+  ad=59.999996p pd=46u as=0 ps=0
M1962 vdd INVX2_149/A OAI21X1_58/C vdd pfet w=20 l=2
+  ad=0 pd=0 as=0 ps=0
M1963 OAI21X1_58/C INVX2_149/A NAND2X1_35/a_9_6# Gnd nfet w=20 l=2
+  ad=100p pd=50u as=0 ps=0
M1964 OAI22X1_9/B NAND2X1_68/A vdd vdd pfet w=20 l=2
+  ad=0.12n pd=52u as=0 ps=0
M1965 NAND2X1_68/a_9_6# NAND2X1_68/A gnd Gnd nfet w=20 l=2
+  ad=59.999996p pd=46u as=0 ps=0
M1966 vdd invader_1_display OAI22X1_9/B vdd pfet w=20 l=2
+  ad=0 pd=0 as=0 ps=0
M1967 OAI22X1_9/B invader_1_display NAND2X1_68/a_9_6# Gnd nfet w=20 l=2
+  ad=100p pd=50u as=0 ps=0
M1968 NAND2X1_79/Y player_coord_x[2] vdd vdd pfet w=20 l=2
+  ad=0.12n pd=52u as=0 ps=0
M1969 NAND2X1_79/a_9_6# player_coord_x[2] gnd Gnd nfet w=20 l=2
+  ad=59.999996p pd=46u as=0 ps=0
M1970 vdd INVX2_64/Y NAND2X1_79/Y vdd pfet w=20 l=2
+  ad=0 pd=0 as=0 ps=0
M1971 NAND2X1_79/Y INVX2_64/Y NAND2X1_79/a_9_6# Gnd nfet w=20 l=2
+  ad=100p pd=50u as=0 ps=0
M1972 gnd AOI22X1_11/C AOI22X1_11/a_28_6# Gnd nfet w=20 l=2
+  ad=0 pd=0 as=59.999996p ps=46u
M1973 OAI21X1_32/C INVX2_94/Y AOI22X1_11/a_11_6# Gnd nfet w=20 l=2
+  ad=0.2n pd=60u as=59.999996p ps=46u
M1974 AOI22X1_11/a_11_6# player_bullet_coord_x[2] gnd Gnd nfet w=20 l=2
+  ad=0 pd=0 as=0 ps=0
M1975 AOI22X1_11/a_2_54# INVX2_94/Y vdd vdd pfet w=40 l=2
+  ad=0.64n pd=0.272m as=0 ps=0
M1976 AOI22X1_11/a_28_6# player_bullet_coord_x[1] OAI21X1_32/C Gnd nfet w=20 l=2
+  ad=0 pd=0 as=0 ps=0
M1977 vdd player_bullet_coord_x[2] AOI22X1_11/a_2_54# vdd pfet w=40 l=2
+  ad=0 pd=0 as=0 ps=0
M1978 OAI21X1_32/C player_bullet_coord_x[1] AOI22X1_11/a_2_54# vdd pfet w=40 l=2
+  ad=0.24n pd=92u as=0 ps=0
M1979 AOI22X1_11/a_2_54# AOI22X1_11/C OAI21X1_32/C vdd pfet w=40 l=2
+  ad=0 pd=0 as=0 ps=0
M1980 gnd player_bullet_coord_x[1] AOI22X1_22/a_28_6# Gnd nfet w=20 l=2
+  ad=0 pd=0 as=59.999996p ps=46u
M1981 INVX2_141/A NOR2X1_26/Y AOI22X1_22/a_11_6# Gnd nfet w=20 l=2
+  ad=0.2n pd=60u as=59.999996p ps=46u
M1982 AOI22X1_22/a_11_6# player_coord_x[1] gnd Gnd nfet w=20 l=2
+  ad=0 pd=0 as=0 ps=0
M1983 AOI22X1_22/a_2_54# NOR2X1_26/Y vdd vdd pfet w=40 l=2
+  ad=0.64n pd=0.272m as=0 ps=0
M1984 AOI22X1_22/a_28_6# AND2X2_0/A INVX2_141/A Gnd nfet w=20 l=2
+  ad=0 pd=0 as=0 ps=0
M1985 vdd player_coord_x[1] AOI22X1_22/a_2_54# vdd pfet w=40 l=2
+  ad=0 pd=0 as=0 ps=0
M1986 INVX2_141/A AND2X2_0/A AOI22X1_22/a_2_54# vdd pfet w=40 l=2
+  ad=0.24n pd=92u as=0 ps=0
M1987 AOI22X1_22/a_2_54# player_bullet_coord_x[1] INVX2_141/A vdd pfet w=40 l=2
+  ad=0 pd=0 as=0 ps=0
M1988 gnd INVX2_65/A AOI22X1_33/a_28_6# Gnd nfet w=20 l=2
+  ad=0 pd=0 as=59.999996p ps=46u
M1989 INVX2_155/A AND2X2_8/A AOI22X1_33/a_11_6# Gnd nfet w=20 l=2
+  ad=0.2n pd=60u as=59.999996p ps=46u
M1990 AOI22X1_33/a_11_6# HAX1_10/YS gnd Gnd nfet w=20 l=2
+  ad=0 pd=0 as=0 ps=0
M1991 AOI22X1_33/a_2_54# AND2X2_8/A vdd vdd pfet w=40 l=2
+  ad=0.64n pd=0.272m as=0 ps=0
M1992 AOI22X1_33/a_28_6# AND2X2_9/B INVX2_155/A Gnd nfet w=20 l=2
+  ad=0 pd=0 as=0 ps=0
M1993 vdd HAX1_10/YS AOI22X1_33/a_2_54# vdd pfet w=40 l=2
+  ad=0 pd=0 as=0 ps=0
M1994 INVX2_155/A AND2X2_9/B AOI22X1_33/a_2_54# vdd pfet w=40 l=2
+  ad=0.24n pd=92u as=0 ps=0
M1995 AOI22X1_33/a_2_54# INVX2_65/A INVX2_155/A vdd pfet w=40 l=2
+  ad=0 pd=0 as=0 ps=0
M1996 gnd INVX2_153/A AOI22X1_44/a_28_6# Gnd nfet w=20 l=2
+  ad=0 pd=0 as=59.999996p ps=46u
M1997 NOR2X1_51/A OR2X1_16/Y AOI22X1_44/a_11_6# Gnd nfet w=20 l=2
+  ad=0.2n pd=60u as=59.999996p ps=46u
M1998 AOI22X1_44/a_11_6# INVX2_96/A gnd Gnd nfet w=20 l=2
+  ad=0 pd=0 as=0 ps=0
M1999 AOI22X1_44/a_2_54# OR2X1_16/Y vdd vdd pfet w=40 l=2
+  ad=0.64n pd=0.272m as=0 ps=0
M2000 AOI22X1_44/a_28_6# INVX2_96/Y NOR2X1_51/A Gnd nfet w=20 l=2
+  ad=0 pd=0 as=0 ps=0
M2001 vdd INVX2_96/A AOI22X1_44/a_2_54# vdd pfet w=40 l=2
+  ad=0 pd=0 as=0 ps=0
M2002 NOR2X1_51/A INVX2_96/Y AOI22X1_44/a_2_54# vdd pfet w=40 l=2
+  ad=0.24n pd=92u as=0 ps=0
M2003 AOI22X1_44/a_2_54# INVX2_153/A NOR2X1_51/A vdd pfet w=40 l=2
+  ad=0 pd=0 as=0 ps=0
M2004 gnd invader_2_coord_y[1] AOI22X1_55/a_28_6# Gnd nfet w=20 l=2
+  ad=0 pd=0 as=59.999996p ps=46u
M2005 INVX2_117/A OAI22X1_8/A AOI22X1_55/a_11_6# Gnd nfet w=20 l=2
+  ad=0.2n pd=60u as=59.999996p ps=46u
M2006 AOI22X1_55/a_11_6# invader_1_coord_y[1] gnd Gnd nfet w=20 l=2
+  ad=0 pd=0 as=0 ps=0
M2007 AOI22X1_55/a_2_54# OAI22X1_8/A vdd vdd pfet w=40 l=2
+  ad=0.64n pd=0.272m as=0 ps=0
M2008 AOI22X1_55/a_28_6# OAI22X1_8/D INVX2_117/A Gnd nfet w=20 l=2
+  ad=0 pd=0 as=0 ps=0
M2009 vdd invader_1_coord_y[1] AOI22X1_55/a_2_54# vdd pfet w=40 l=2
+  ad=0 pd=0 as=0 ps=0
M2010 INVX2_117/A OAI22X1_8/D AOI22X1_55/a_2_54# vdd pfet w=40 l=2
+  ad=0.24n pd=92u as=0 ps=0
M2011 AOI22X1_55/a_2_54# invader_2_coord_y[1] INVX2_117/A vdd pfet w=40 l=2
+  ad=0 pd=0 as=0 ps=0
M2012 gnd OAI22X1_8/A OAI22X1_6/a_2_6# Gnd nfet w=20 l=2
+  ad=0 pd=0 as=0.32n ps=0.152m
M2013 OAI22X1_6/a_2_6# INVX2_64/Y OAI22X1_6/Y Gnd nfet w=20 l=2
+  ad=0 pd=0 as=0.12n ps=52u
M2014 OAI22X1_6/Y OAI22X1_8/D OAI22X1_6/a_2_6# Gnd nfet w=20 l=2
+  ad=0 pd=0 as=0 ps=0
M2015 OAI22X1_6/Y INVX2_44/Y OAI22X1_6/a_9_54# vdd pfet w=40 l=2
+  ad=0.48n pd=0.104m as=0.12n ps=86u
M2016 OAI22X1_6/a_28_54# OAI22X1_8/D OAI22X1_6/Y vdd pfet w=40 l=2
+  ad=0.12n pd=86u as=0 ps=0
M2017 OAI22X1_6/a_9_54# OAI22X1_8/A vdd vdd pfet w=40 l=2
+  ad=0 pd=0 as=0 ps=0
M2018 OAI22X1_6/a_2_6# INVX2_44/Y gnd Gnd nfet w=20 l=2
+  ad=0 pd=0 as=0 ps=0
M2019 vdd INVX2_64/Y OAI22X1_6/a_28_54# vdd pfet w=40 l=2
+  ad=0 pd=0 as=0 ps=0
M2020 INVX2_15/Y player_bullet_coord_y[2] gnd Gnd nfet w=20 l=2
+  ad=100p pd=50u as=0 ps=0
M2021 INVX2_15/Y player_bullet_coord_y[2] vdd vdd pfet w=40 l=2
+  ad=0.2n pd=90u as=0 ps=0
M2022 INVX2_26/Y INVX2_26/A gnd Gnd nfet w=20 l=2
+  ad=100p pd=50u as=0 ps=0
M2023 INVX2_26/Y INVX2_26/A vdd vdd pfet w=40 l=2
+  ad=0.2n pd=90u as=0 ps=0
M2024 INVX2_48/Y INVX2_48/A gnd Gnd nfet w=20 l=2
+  ad=100p pd=50u as=0 ps=0
M2025 INVX2_48/Y INVX2_48/A vdd vdd pfet w=40 l=2
+  ad=0.2n pd=90u as=0 ps=0
M2026 INVX2_37/Y INVX2_37/A gnd Gnd nfet w=20 l=2
+  ad=100p pd=50u as=0 ps=0
M2027 INVX2_37/Y INVX2_37/A vdd vdd pfet w=40 l=2
+  ad=0.2n pd=90u as=0 ps=0
M2028 INVX2_59/Y INVX2_59/A gnd Gnd nfet w=20 l=2
+  ad=100p pd=50u as=0 ps=0
M2029 INVX2_59/Y INVX2_59/A vdd vdd pfet w=40 l=2
+  ad=0.2n pd=90u as=0 ps=0
M2030 INVX2_160/Y NOR2X1_45/Y gnd Gnd nfet w=20 l=2
+  ad=100p pd=50u as=0 ps=0
M2031 INVX2_160/Y NOR2X1_45/Y vdd vdd pfet w=40 l=2
+  ad=0.2n pd=90u as=0 ps=0
M2032 INVX2_171/Y INVX2_171/A gnd Gnd nfet w=20 l=2
+  ad=100p pd=50u as=0 ps=0
M2033 INVX2_171/Y INVX2_171/A vdd vdd pfet w=40 l=2
+  ad=0.2n pd=90u as=0 ps=0
M2034 INVX2_182/Y player_coord_x[3] gnd Gnd nfet w=20 l=2
+  ad=100p pd=50u as=0 ps=0
M2035 INVX2_182/Y player_coord_x[3] vdd vdd pfet w=40 l=2
+  ad=0.2n pd=90u as=0 ps=0
M2036 DFFNEGX1_11/a_76_6# BUFX2_7/Y DFFNEGX1_11/a_66_6# Gnd nfet w=10 l=2
+  ad=29.999998p pd=26u as=80p ps=36u
M2037 gnd BUFX2_7/Y DFFNEGX1_11/a_2_6# Gnd nfet w=20 l=2
+  ad=0 pd=0 as=100p ps=50u
M2038 DFFNEGX1_11/a_66_6# DFFNEGX1_11/a_2_6# DFFNEGX1_11/a_61_6# Gnd nfet w=10 l=2
+  ad=0 pd=0 as=29.999998p ps=26u
M2039 player_bullet_coord_y[0] DFFNEGX1_11/a_66_6# gnd Gnd nfet w=20 l=2
+  ad=100p pd=50u as=0 ps=0
M2040 DFFNEGX1_11/a_23_6# BUFX2_7/Y DFFNEGX1_11/a_17_6# Gnd nfet w=10 l=2
+  ad=59.999996p pd=32u as=40p ps=28u
M2041 DFFNEGX1_11/a_23_6# DFFNEGX1_11/a_2_6# DFFNEGX1_11/a_17_74# vdd pfet w=20 l=2
+  ad=0.12n pd=52u as=80p ps=48u
M2042 gnd DFFNEGX1_11/a_34_4# DFFNEGX1_11/a_31_6# Gnd nfet w=10 l=2
+  ad=0 pd=0 as=29.999998p ps=26u
M2043 vdd DFFNEGX1_11/a_34_4# DFFNEGX1_11/a_31_74# vdd pfet w=20 l=2
+  ad=0 pd=0 as=80p ps=48u
M2044 DFFNEGX1_11/a_61_74# DFFNEGX1_11/a_34_4# vdd vdd pfet w=20 l=2
+  ad=59.999996p pd=46u as=0 ps=0
M2045 DFFNEGX1_11/a_34_4# DFFNEGX1_11/a_23_6# vdd vdd pfet w=20 l=2
+  ad=100p pd=50u as=0 ps=0
M2046 DFFNEGX1_11/a_34_4# DFFNEGX1_11/a_23_6# gnd Gnd nfet w=10 l=2
+  ad=50p pd=30u as=0 ps=0
M2047 vdd player_bullet_coord_y[0] DFFNEGX1_11/a_76_84# vdd pfet w=10 l=2
+  ad=0 pd=0 as=29.999998p ps=26u
M2048 gnd player_bullet_coord_y[0] DFFNEGX1_11/a_76_6# Gnd nfet w=10 l=2
+  ad=0 pd=0 as=0 ps=0
M2049 DFFNEGX1_11/a_61_6# DFFNEGX1_11/a_34_4# gnd Gnd nfet w=10 l=2
+  ad=0 pd=0 as=0 ps=0
M2050 DFFNEGX1_11/a_76_84# DFFNEGX1_11/a_2_6# DFFNEGX1_11/a_66_6# vdd pfet w=10 l=2
+  ad=0 pd=0 as=0.15n ps=56u
M2051 player_bullet_coord_y[0] DFFNEGX1_11/a_66_6# vdd vdd pfet w=40 l=2
+  ad=0.2n pd=90u as=0 ps=0
M2052 vdd BUFX2_7/Y DFFNEGX1_11/a_2_6# vdd pfet w=40 l=2
+  ad=0 pd=0 as=0.2n ps=90u
M2053 DFFNEGX1_11/a_31_6# DFFNEGX1_11/a_2_6# DFFNEGX1_11/a_23_6# Gnd nfet w=10 l=2
+  ad=0 pd=0 as=0 ps=0
M2054 DFFNEGX1_11/a_66_6# BUFX2_7/Y DFFNEGX1_11/a_61_74# vdd pfet w=20 l=2
+  ad=0 pd=0 as=0 ps=0
M2055 DFFNEGX1_11/a_17_74# NOR2X1_3/Y vdd vdd pfet w=20 l=2
+  ad=0 pd=0 as=0 ps=0
M2056 DFFNEGX1_11/a_31_74# BUFX2_7/Y DFFNEGX1_11/a_23_6# vdd pfet w=20 l=2
+  ad=0 pd=0 as=0 ps=0
M2057 DFFNEGX1_11/a_17_6# NOR2X1_3/Y gnd Gnd nfet w=10 l=2
+  ad=0 pd=0 as=0 ps=0
M2058 DFFNEGX1_33/a_76_6# BUFX2_5/Y DFFNEGX1_33/a_66_6# Gnd nfet w=10 l=2
+  ad=29.999998p pd=26u as=80p ps=36u
M2059 gnd BUFX2_5/Y DFFNEGX1_33/a_2_6# Gnd nfet w=20 l=2
+  ad=0 pd=0 as=100p ps=50u
M2060 DFFNEGX1_33/a_66_6# DFFNEGX1_33/a_2_6# DFFNEGX1_33/a_61_6# Gnd nfet w=10 l=2
+  ad=0 pd=0 as=29.999998p ps=26u
M2061 invader_2_coord_y[3] DFFNEGX1_33/a_66_6# gnd Gnd nfet w=20 l=2
+  ad=100p pd=50u as=0 ps=0
M2062 DFFNEGX1_33/a_23_6# BUFX2_5/Y DFFNEGX1_33/a_17_6# Gnd nfet w=10 l=2
+  ad=59.999996p pd=32u as=40p ps=28u
M2063 DFFNEGX1_33/a_23_6# DFFNEGX1_33/a_2_6# DFFNEGX1_33/a_17_74# vdd pfet w=20 l=2
+  ad=0.12n pd=52u as=80p ps=48u
M2064 gnd DFFNEGX1_33/a_34_4# DFFNEGX1_33/a_31_6# Gnd nfet w=10 l=2
+  ad=0 pd=0 as=29.999998p ps=26u
M2065 vdd DFFNEGX1_33/a_34_4# DFFNEGX1_33/a_31_74# vdd pfet w=20 l=2
+  ad=0 pd=0 as=80p ps=48u
M2066 DFFNEGX1_33/a_61_74# DFFNEGX1_33/a_34_4# vdd vdd pfet w=20 l=2
+  ad=59.999996p pd=46u as=0 ps=0
M2067 DFFNEGX1_33/a_34_4# DFFNEGX1_33/a_23_6# vdd vdd pfet w=20 l=2
+  ad=100p pd=50u as=0 ps=0
M2068 DFFNEGX1_33/a_34_4# DFFNEGX1_33/a_23_6# gnd Gnd nfet w=10 l=2
+  ad=50p pd=30u as=0 ps=0
M2069 vdd invader_2_coord_y[3] DFFNEGX1_33/a_76_84# vdd pfet w=10 l=2
+  ad=0 pd=0 as=29.999998p ps=26u
M2070 gnd invader_2_coord_y[3] DFFNEGX1_33/a_76_6# Gnd nfet w=10 l=2
+  ad=0 pd=0 as=0 ps=0
M2071 DFFNEGX1_33/a_61_6# DFFNEGX1_33/a_34_4# gnd Gnd nfet w=10 l=2
+  ad=0 pd=0 as=0 ps=0
M2072 DFFNEGX1_33/a_76_84# DFFNEGX1_33/a_2_6# DFFNEGX1_33/a_66_6# vdd pfet w=10 l=2
+  ad=0 pd=0 as=0.15n ps=56u
M2073 invader_2_coord_y[3] DFFNEGX1_33/a_66_6# vdd vdd pfet w=40 l=2
+  ad=0.2n pd=90u as=0 ps=0
M2074 vdd BUFX2_5/Y DFFNEGX1_33/a_2_6# vdd pfet w=40 l=2
+  ad=0 pd=0 as=0.2n ps=90u
M2075 DFFNEGX1_33/a_31_6# DFFNEGX1_33/a_2_6# DFFNEGX1_33/a_23_6# Gnd nfet w=10 l=2
+  ad=0 pd=0 as=0 ps=0
M2076 DFFNEGX1_33/a_66_6# BUFX2_5/Y DFFNEGX1_33/a_61_74# vdd pfet w=20 l=2
+  ad=0 pd=0 as=0 ps=0
M2077 DFFNEGX1_33/a_17_74# NAND3X1_18/Y vdd vdd pfet w=20 l=2
+  ad=0 pd=0 as=0 ps=0
M2078 DFFNEGX1_33/a_31_74# BUFX2_5/Y DFFNEGX1_33/a_23_6# vdd pfet w=20 l=2
+  ad=0 pd=0 as=0 ps=0
M2079 DFFNEGX1_33/a_17_6# NAND3X1_18/Y gnd Gnd nfet w=10 l=2
+  ad=0 pd=0 as=0 ps=0
M2080 DFFNEGX1_22/a_76_6# BUFX2_6/Y DFFNEGX1_22/a_66_6# Gnd nfet w=10 l=2
+  ad=29.999998p pd=26u as=80p ps=36u
M2081 gnd BUFX2_6/Y DFFNEGX1_22/a_2_6# Gnd nfet w=20 l=2
+  ad=0 pd=0 as=100p ps=50u
M2082 DFFNEGX1_22/a_66_6# DFFNEGX1_22/a_2_6# DFFNEGX1_22/a_61_6# Gnd nfet w=10 l=2
+  ad=0 pd=0 as=29.999998p ps=26u
M2083 invader_2_coord_x[0] DFFNEGX1_22/a_66_6# gnd Gnd nfet w=20 l=2
+  ad=100p pd=50u as=0 ps=0
M2084 DFFNEGX1_22/a_23_6# BUFX2_6/Y DFFNEGX1_22/a_17_6# Gnd nfet w=10 l=2
+  ad=59.999996p pd=32u as=40p ps=28u
M2085 DFFNEGX1_22/a_23_6# DFFNEGX1_22/a_2_6# DFFNEGX1_22/a_17_74# vdd pfet w=20 l=2
+  ad=0.12n pd=52u as=80p ps=48u
M2086 gnd DFFNEGX1_22/a_34_4# DFFNEGX1_22/a_31_6# Gnd nfet w=10 l=2
+  ad=0 pd=0 as=29.999998p ps=26u
M2087 vdd DFFNEGX1_22/a_34_4# DFFNEGX1_22/a_31_74# vdd pfet w=20 l=2
+  ad=0 pd=0 as=80p ps=48u
M2088 DFFNEGX1_22/a_61_74# DFFNEGX1_22/a_34_4# vdd vdd pfet w=20 l=2
+  ad=59.999996p pd=46u as=0 ps=0
M2089 DFFNEGX1_22/a_34_4# DFFNEGX1_22/a_23_6# vdd vdd pfet w=20 l=2
+  ad=100p pd=50u as=0 ps=0
M2090 DFFNEGX1_22/a_34_4# DFFNEGX1_22/a_23_6# gnd Gnd nfet w=10 l=2
+  ad=50p pd=30u as=0 ps=0
M2091 vdd invader_2_coord_x[0] DFFNEGX1_22/a_76_84# vdd pfet w=10 l=2
+  ad=0 pd=0 as=29.999998p ps=26u
M2092 gnd invader_2_coord_x[0] DFFNEGX1_22/a_76_6# Gnd nfet w=10 l=2
+  ad=0 pd=0 as=0 ps=0
M2093 DFFNEGX1_22/a_61_6# DFFNEGX1_22/a_34_4# gnd Gnd nfet w=10 l=2
+  ad=0 pd=0 as=0 ps=0
M2094 DFFNEGX1_22/a_76_84# DFFNEGX1_22/a_2_6# DFFNEGX1_22/a_66_6# vdd pfet w=10 l=2
+  ad=0 pd=0 as=0.15n ps=56u
M2095 invader_2_coord_x[0] DFFNEGX1_22/a_66_6# vdd vdd pfet w=40 l=2
+  ad=0.2n pd=90u as=0 ps=0
M2096 vdd BUFX2_6/Y DFFNEGX1_22/a_2_6# vdd pfet w=40 l=2
+  ad=0 pd=0 as=0.2n ps=90u
M2097 DFFNEGX1_22/a_31_6# DFFNEGX1_22/a_2_6# DFFNEGX1_22/a_23_6# Gnd nfet w=10 l=2
+  ad=0 pd=0 as=0 ps=0
M2098 DFFNEGX1_22/a_66_6# BUFX2_6/Y DFFNEGX1_22/a_61_74# vdd pfet w=20 l=2
+  ad=0 pd=0 as=0 ps=0
M2099 DFFNEGX1_22/a_17_74# OAI21X1_66/Y vdd vdd pfet w=20 l=2
+  ad=0 pd=0 as=0 ps=0
M2100 DFFNEGX1_22/a_31_74# BUFX2_6/Y DFFNEGX1_22/a_23_6# vdd pfet w=20 l=2
+  ad=0 pd=0 as=0 ps=0
M2101 DFFNEGX1_22/a_17_6# OAI21X1_66/Y gnd Gnd nfet w=10 l=2
+  ad=0 pd=0 as=0 ps=0
M2102 DFFNEGX1_66/a_76_6# clka DFFNEGX1_66/a_66_6# Gnd nfet w=10 l=2
+  ad=29.999998p pd=26u as=80p ps=36u
M2103 gnd clka DFFNEGX1_66/a_2_6# Gnd nfet w=20 l=2
+  ad=0 pd=0 as=100p ps=50u
M2104 DFFNEGX1_66/a_66_6# DFFNEGX1_66/a_2_6# DFFNEGX1_66/a_61_6# Gnd nfet w=10 l=2
+  ad=0 pd=0 as=29.999998p ps=26u
M2105 INVX2_95/A DFFNEGX1_66/a_66_6# gnd Gnd nfet w=20 l=2
+  ad=100p pd=50u as=0 ps=0
M2106 DFFNEGX1_66/a_23_6# clka DFFNEGX1_66/a_17_6# Gnd nfet w=10 l=2
+  ad=59.999996p pd=32u as=40p ps=28u
M2107 DFFNEGX1_66/a_23_6# DFFNEGX1_66/a_2_6# DFFNEGX1_66/a_17_74# vdd pfet w=20 l=2
+  ad=0.12n pd=52u as=80p ps=48u
M2108 gnd DFFNEGX1_66/a_34_4# DFFNEGX1_66/a_31_6# Gnd nfet w=10 l=2
+  ad=0 pd=0 as=29.999998p ps=26u
M2109 vdd DFFNEGX1_66/a_34_4# DFFNEGX1_66/a_31_74# vdd pfet w=20 l=2
+  ad=0 pd=0 as=80p ps=48u
M2110 DFFNEGX1_66/a_61_74# DFFNEGX1_66/a_34_4# vdd vdd pfet w=20 l=2
+  ad=59.999996p pd=46u as=0 ps=0
M2111 DFFNEGX1_66/a_34_4# DFFNEGX1_66/a_23_6# vdd vdd pfet w=20 l=2
+  ad=100p pd=50u as=0 ps=0
M2112 DFFNEGX1_66/a_34_4# DFFNEGX1_66/a_23_6# gnd Gnd nfet w=10 l=2
+  ad=50p pd=30u as=0 ps=0
M2113 vdd INVX2_95/A DFFNEGX1_66/a_76_84# vdd pfet w=10 l=2
+  ad=0 pd=0 as=29.999998p ps=26u
M2114 gnd INVX2_95/A DFFNEGX1_66/a_76_6# Gnd nfet w=10 l=2
+  ad=0 pd=0 as=0 ps=0
M2115 DFFNEGX1_66/a_61_6# DFFNEGX1_66/a_34_4# gnd Gnd nfet w=10 l=2
+  ad=0 pd=0 as=0 ps=0
M2116 DFFNEGX1_66/a_76_84# DFFNEGX1_66/a_2_6# DFFNEGX1_66/a_66_6# vdd pfet w=10 l=2
+  ad=0 pd=0 as=0.15n ps=56u
M2117 INVX2_95/A DFFNEGX1_66/a_66_6# vdd vdd pfet w=40 l=2
+  ad=0.2n pd=90u as=0 ps=0
M2118 vdd clka DFFNEGX1_66/a_2_6# vdd pfet w=40 l=2
+  ad=0 pd=0 as=0.2n ps=90u
M2119 DFFNEGX1_66/a_31_6# DFFNEGX1_66/a_2_6# DFFNEGX1_66/a_23_6# Gnd nfet w=10 l=2
+  ad=0 pd=0 as=0 ps=0
M2120 DFFNEGX1_66/a_66_6# clka DFFNEGX1_66/a_61_74# vdd pfet w=20 l=2
+  ad=0 pd=0 as=0 ps=0
M2121 DFFNEGX1_66/a_17_74# NOR2X1_51/Y vdd vdd pfet w=20 l=2
+  ad=0 pd=0 as=0 ps=0
M2122 DFFNEGX1_66/a_31_74# clka DFFNEGX1_66/a_23_6# vdd pfet w=20 l=2
+  ad=0 pd=0 as=0 ps=0
M2123 DFFNEGX1_66/a_17_6# NOR2X1_51/Y gnd Gnd nfet w=10 l=2
+  ad=0 pd=0 as=0 ps=0
M2124 DFFNEGX1_55/a_76_6# BUFX2_4/Y DFFNEGX1_55/a_66_6# Gnd nfet w=10 l=2
+  ad=29.999998p pd=26u as=80p ps=36u
M2125 gnd BUFX2_4/Y DFFNEGX1_55/a_2_6# Gnd nfet w=20 l=2
+  ad=0 pd=0 as=100p ps=50u
M2126 DFFNEGX1_55/a_66_6# DFFNEGX1_55/a_2_6# DFFNEGX1_55/a_61_6# Gnd nfet w=10 l=2
+  ad=0 pd=0 as=29.999998p ps=26u
M2127 shield_hp[1] DFFNEGX1_55/a_66_6# gnd Gnd nfet w=20 l=2
+  ad=100p pd=50u as=0 ps=0
M2128 DFFNEGX1_55/a_23_6# BUFX2_4/Y DFFNEGX1_55/a_17_6# Gnd nfet w=10 l=2
+  ad=59.999996p pd=32u as=40p ps=28u
M2129 DFFNEGX1_55/a_23_6# DFFNEGX1_55/a_2_6# DFFNEGX1_55/a_17_74# vdd pfet w=20 l=2
+  ad=0.12n pd=52u as=80p ps=48u
M2130 gnd DFFNEGX1_55/a_34_4# DFFNEGX1_55/a_31_6# Gnd nfet w=10 l=2
+  ad=0 pd=0 as=29.999998p ps=26u
M2131 vdd DFFNEGX1_55/a_34_4# DFFNEGX1_55/a_31_74# vdd pfet w=20 l=2
+  ad=0 pd=0 as=80p ps=48u
M2132 DFFNEGX1_55/a_61_74# DFFNEGX1_55/a_34_4# vdd vdd pfet w=20 l=2
+  ad=59.999996p pd=46u as=0 ps=0
M2133 DFFNEGX1_55/a_34_4# DFFNEGX1_55/a_23_6# vdd vdd pfet w=20 l=2
+  ad=100p pd=50u as=0 ps=0
M2134 DFFNEGX1_55/a_34_4# DFFNEGX1_55/a_23_6# gnd Gnd nfet w=10 l=2
+  ad=50p pd=30u as=0 ps=0
M2135 vdd shield_hp[1] DFFNEGX1_55/a_76_84# vdd pfet w=10 l=2
+  ad=0 pd=0 as=29.999998p ps=26u
M2136 gnd shield_hp[1] DFFNEGX1_55/a_76_6# Gnd nfet w=10 l=2
+  ad=0 pd=0 as=0 ps=0
M2137 DFFNEGX1_55/a_61_6# DFFNEGX1_55/a_34_4# gnd Gnd nfet w=10 l=2
+  ad=0 pd=0 as=0 ps=0
M2138 DFFNEGX1_55/a_76_84# DFFNEGX1_55/a_2_6# DFFNEGX1_55/a_66_6# vdd pfet w=10 l=2
+  ad=0 pd=0 as=0.15n ps=56u
M2139 shield_hp[1] DFFNEGX1_55/a_66_6# vdd vdd pfet w=40 l=2
+  ad=0.2n pd=90u as=0 ps=0
M2140 vdd BUFX2_4/Y DFFNEGX1_55/a_2_6# vdd pfet w=40 l=2
+  ad=0 pd=0 as=0.2n ps=90u
M2141 DFFNEGX1_55/a_31_6# DFFNEGX1_55/a_2_6# DFFNEGX1_55/a_23_6# Gnd nfet w=10 l=2
+  ad=0 pd=0 as=0 ps=0
M2142 DFFNEGX1_55/a_66_6# BUFX2_4/Y DFFNEGX1_55/a_61_74# vdd pfet w=20 l=2
+  ad=0 pd=0 as=0 ps=0
M2143 DFFNEGX1_55/a_17_74# NAND2X1_48/Y vdd vdd pfet w=20 l=2
+  ad=0 pd=0 as=0 ps=0
M2144 DFFNEGX1_55/a_31_74# BUFX2_4/Y DFFNEGX1_55/a_23_6# vdd pfet w=20 l=2
+  ad=0 pd=0 as=0 ps=0
M2145 DFFNEGX1_55/a_17_6# NAND2X1_48/Y gnd Gnd nfet w=10 l=2
+  ad=0 pd=0 as=0 ps=0
M2146 DFFNEGX1_77/a_76_6# clka DFFNEGX1_77/a_66_6# Gnd nfet w=10 l=2
+  ad=29.999998p pd=26u as=80p ps=36u
M2147 gnd clka DFFNEGX1_77/a_2_6# Gnd nfet w=20 l=2
+  ad=0 pd=0 as=100p ps=50u
M2148 DFFNEGX1_77/a_66_6# DFFNEGX1_77/a_2_6# DFFNEGX1_77/a_61_6# Gnd nfet w=10 l=2
+  ad=0 pd=0 as=29.999998p ps=26u
M2149 INVX2_125/A DFFNEGX1_77/a_66_6# gnd Gnd nfet w=20 l=2
+  ad=100p pd=50u as=0 ps=0
M2150 DFFNEGX1_77/a_23_6# clka DFFNEGX1_77/a_17_6# Gnd nfet w=10 l=2
+  ad=59.999996p pd=32u as=40p ps=28u
M2151 DFFNEGX1_77/a_23_6# DFFNEGX1_77/a_2_6# DFFNEGX1_77/a_17_74# vdd pfet w=20 l=2
+  ad=0.12n pd=52u as=80p ps=48u
M2152 gnd DFFNEGX1_77/a_34_4# DFFNEGX1_77/a_31_6# Gnd nfet w=10 l=2
+  ad=0 pd=0 as=29.999998p ps=26u
M2153 vdd DFFNEGX1_77/a_34_4# DFFNEGX1_77/a_31_74# vdd pfet w=20 l=2
+  ad=0 pd=0 as=80p ps=48u
M2154 DFFNEGX1_77/a_61_74# DFFNEGX1_77/a_34_4# vdd vdd pfet w=20 l=2
+  ad=59.999996p pd=46u as=0 ps=0
M2155 DFFNEGX1_77/a_34_4# DFFNEGX1_77/a_23_6# vdd vdd pfet w=20 l=2
+  ad=100p pd=50u as=0 ps=0
M2156 DFFNEGX1_77/a_34_4# DFFNEGX1_77/a_23_6# gnd Gnd nfet w=10 l=2
+  ad=50p pd=30u as=0 ps=0
M2157 vdd INVX2_125/A DFFNEGX1_77/a_76_84# vdd pfet w=10 l=2
+  ad=0 pd=0 as=29.999998p ps=26u
M2158 gnd INVX2_125/A DFFNEGX1_77/a_76_6# Gnd nfet w=10 l=2
+  ad=0 pd=0 as=0 ps=0
M2159 DFFNEGX1_77/a_61_6# DFFNEGX1_77/a_34_4# gnd Gnd nfet w=10 l=2
+  ad=0 pd=0 as=0 ps=0
M2160 DFFNEGX1_77/a_76_84# DFFNEGX1_77/a_2_6# DFFNEGX1_77/a_66_6# vdd pfet w=10 l=2
+  ad=0 pd=0 as=0.15n ps=56u
M2161 INVX2_125/A DFFNEGX1_77/a_66_6# vdd vdd pfet w=40 l=2
+  ad=0.2n pd=90u as=0 ps=0
M2162 vdd clka DFFNEGX1_77/a_2_6# vdd pfet w=40 l=2
+  ad=0 pd=0 as=0.2n ps=90u
M2163 DFFNEGX1_77/a_31_6# DFFNEGX1_77/a_2_6# DFFNEGX1_77/a_23_6# Gnd nfet w=10 l=2
+  ad=0 pd=0 as=0 ps=0
M2164 DFFNEGX1_77/a_66_6# clka DFFNEGX1_77/a_61_74# vdd pfet w=20 l=2
+  ad=0 pd=0 as=0 ps=0
M2165 DFFNEGX1_77/a_17_74# AOI21X1_29/Y vdd vdd pfet w=20 l=2
+  ad=0 pd=0 as=0 ps=0
M2166 DFFNEGX1_77/a_31_74# clka DFFNEGX1_77/a_23_6# vdd pfet w=20 l=2
+  ad=0 pd=0 as=0 ps=0
M2167 DFFNEGX1_77/a_17_6# AOI21X1_29/Y gnd Gnd nfet w=10 l=2
+  ad=0 pd=0 as=0 ps=0
M2168 DFFNEGX1_44/a_76_6# BUFX2_5/Y DFFNEGX1_44/a_66_6# Gnd nfet w=10 l=2
+  ad=29.999998p pd=26u as=80p ps=36u
M2169 gnd BUFX2_5/Y DFFNEGX1_44/a_2_6# Gnd nfet w=20 l=2
+  ad=0 pd=0 as=100p ps=50u
M2170 DFFNEGX1_44/a_66_6# DFFNEGX1_44/a_2_6# DFFNEGX1_44/a_61_6# Gnd nfet w=10 l=2
+  ad=0 pd=0 as=29.999998p ps=26u
M2171 invader_1_display DFFNEGX1_44/a_66_6# gnd Gnd nfet w=20 l=2
+  ad=100p pd=50u as=0 ps=0
M2172 DFFNEGX1_44/a_23_6# BUFX2_5/Y DFFNEGX1_44/a_17_6# Gnd nfet w=10 l=2
+  ad=59.999996p pd=32u as=40p ps=28u
M2173 DFFNEGX1_44/a_23_6# DFFNEGX1_44/a_2_6# DFFNEGX1_44/a_17_74# vdd pfet w=20 l=2
+  ad=0.12n pd=52u as=80p ps=48u
M2174 gnd DFFNEGX1_44/a_34_4# DFFNEGX1_44/a_31_6# Gnd nfet w=10 l=2
+  ad=0 pd=0 as=29.999998p ps=26u
M2175 vdd DFFNEGX1_44/a_34_4# DFFNEGX1_44/a_31_74# vdd pfet w=20 l=2
+  ad=0 pd=0 as=80p ps=48u
M2176 DFFNEGX1_44/a_61_74# DFFNEGX1_44/a_34_4# vdd vdd pfet w=20 l=2
+  ad=59.999996p pd=46u as=0 ps=0
M2177 DFFNEGX1_44/a_34_4# DFFNEGX1_44/a_23_6# vdd vdd pfet w=20 l=2
+  ad=100p pd=50u as=0 ps=0
M2178 DFFNEGX1_44/a_34_4# DFFNEGX1_44/a_23_6# gnd Gnd nfet w=10 l=2
+  ad=50p pd=30u as=0 ps=0
M2179 vdd invader_1_display DFFNEGX1_44/a_76_84# vdd pfet w=10 l=2
+  ad=0 pd=0 as=29.999998p ps=26u
M2180 gnd invader_1_display DFFNEGX1_44/a_76_6# Gnd nfet w=10 l=2
+  ad=0 pd=0 as=0 ps=0
M2181 DFFNEGX1_44/a_61_6# DFFNEGX1_44/a_34_4# gnd Gnd nfet w=10 l=2
+  ad=0 pd=0 as=0 ps=0
M2182 DFFNEGX1_44/a_76_84# DFFNEGX1_44/a_2_6# DFFNEGX1_44/a_66_6# vdd pfet w=10 l=2
+  ad=0 pd=0 as=0.15n ps=56u
M2183 invader_1_display DFFNEGX1_44/a_66_6# vdd vdd pfet w=40 l=2
+  ad=0.2n pd=90u as=0 ps=0
M2184 vdd BUFX2_5/Y DFFNEGX1_44/a_2_6# vdd pfet w=40 l=2
+  ad=0 pd=0 as=0.2n ps=90u
M2185 DFFNEGX1_44/a_31_6# DFFNEGX1_44/a_2_6# DFFNEGX1_44/a_23_6# Gnd nfet w=10 l=2
+  ad=0 pd=0 as=0 ps=0
M2186 DFFNEGX1_44/a_66_6# BUFX2_5/Y DFFNEGX1_44/a_61_74# vdd pfet w=20 l=2
+  ad=0 pd=0 as=0 ps=0
M2187 DFFNEGX1_44/a_17_74# OAI21X1_85/Y vdd vdd pfet w=20 l=2
+  ad=0 pd=0 as=0 ps=0
M2188 DFFNEGX1_44/a_31_74# BUFX2_5/Y DFFNEGX1_44/a_23_6# vdd pfet w=20 l=2
+  ad=0 pd=0 as=0 ps=0
M2189 DFFNEGX1_44/a_17_6# OAI21X1_85/Y gnd Gnd nfet w=10 l=2
+  ad=0 pd=0 as=0 ps=0
M2190 DFFNEGX1_88/a_76_6# clka DFFNEGX1_88/a_66_6# Gnd nfet w=10 l=2
+  ad=29.999998p pd=26u as=80p ps=36u
M2191 gnd clka DFFNEGX1_88/a_2_6# Gnd nfet w=20 l=2
+  ad=0 pd=0 as=100p ps=50u
M2192 DFFNEGX1_88/a_66_6# DFFNEGX1_88/a_2_6# DFFNEGX1_88/a_61_6# Gnd nfet w=10 l=2
+  ad=0 pd=0 as=29.999998p ps=26u
M2193 AOI22X1_49/A DFFNEGX1_88/a_66_6# gnd Gnd nfet w=20 l=2
+  ad=100p pd=50u as=0 ps=0
M2194 DFFNEGX1_88/a_23_6# clka DFFNEGX1_88/a_17_6# Gnd nfet w=10 l=2
+  ad=59.999996p pd=32u as=40p ps=28u
M2195 DFFNEGX1_88/a_23_6# DFFNEGX1_88/a_2_6# DFFNEGX1_88/a_17_74# vdd pfet w=20 l=2
+  ad=0.12n pd=52u as=80p ps=48u
M2196 gnd DFFNEGX1_88/a_34_4# DFFNEGX1_88/a_31_6# Gnd nfet w=10 l=2
+  ad=0 pd=0 as=29.999998p ps=26u
M2197 vdd DFFNEGX1_88/a_34_4# DFFNEGX1_88/a_31_74# vdd pfet w=20 l=2
+  ad=0 pd=0 as=80p ps=48u
M2198 DFFNEGX1_88/a_61_74# DFFNEGX1_88/a_34_4# vdd vdd pfet w=20 l=2
+  ad=59.999996p pd=46u as=0 ps=0
M2199 DFFNEGX1_88/a_34_4# DFFNEGX1_88/a_23_6# vdd vdd pfet w=20 l=2
+  ad=100p pd=50u as=0 ps=0
M2200 DFFNEGX1_88/a_34_4# DFFNEGX1_88/a_23_6# gnd Gnd nfet w=10 l=2
+  ad=50p pd=30u as=0 ps=0
M2201 vdd AOI22X1_49/A DFFNEGX1_88/a_76_84# vdd pfet w=10 l=2
+  ad=0 pd=0 as=29.999998p ps=26u
M2202 gnd AOI22X1_49/A DFFNEGX1_88/a_76_6# Gnd nfet w=10 l=2
+  ad=0 pd=0 as=0 ps=0
M2203 DFFNEGX1_88/a_61_6# DFFNEGX1_88/a_34_4# gnd Gnd nfet w=10 l=2
+  ad=0 pd=0 as=0 ps=0
M2204 DFFNEGX1_88/a_76_84# DFFNEGX1_88/a_2_6# DFFNEGX1_88/a_66_6# vdd pfet w=10 l=2
+  ad=0 pd=0 as=0.15n ps=56u
M2205 AOI22X1_49/A DFFNEGX1_88/a_66_6# vdd vdd pfet w=40 l=2
+  ad=0.2n pd=90u as=0 ps=0
M2206 vdd clka DFFNEGX1_88/a_2_6# vdd pfet w=40 l=2
+  ad=0 pd=0 as=0.2n ps=90u
M2207 DFFNEGX1_88/a_31_6# DFFNEGX1_88/a_2_6# DFFNEGX1_88/a_23_6# Gnd nfet w=10 l=2
+  ad=0 pd=0 as=0 ps=0
M2208 DFFNEGX1_88/a_66_6# clka DFFNEGX1_88/a_61_74# vdd pfet w=20 l=2
+  ad=0 pd=0 as=0 ps=0
M2209 DFFNEGX1_88/a_17_74# AND2X2_22/Y vdd vdd pfet w=20 l=2
+  ad=0 pd=0 as=0 ps=0
M2210 DFFNEGX1_88/a_31_74# clka DFFNEGX1_88/a_23_6# vdd pfet w=20 l=2
+  ad=0 pd=0 as=0 ps=0
M2211 DFFNEGX1_88/a_17_6# AND2X2_22/Y gnd Gnd nfet w=10 l=2
+  ad=0 pd=0 as=0 ps=0
M2212 AND2X2_9/a_2_6# AND2X2_9/A vdd vdd pfet w=20 l=2
+  ad=0.12n pd=52u as=0 ps=0
M2213 AND2X2_9/a_9_6# AND2X2_9/A AND2X2_9/a_2_6# Gnd nfet w=20 l=2
+  ad=59.999996p pd=46u as=100p ps=50u
M2214 AND2X2_9/Y AND2X2_9/a_2_6# gnd Gnd nfet w=20 l=2
+  ad=100p pd=50u as=0 ps=0
M2215 AND2X2_9/Y AND2X2_9/a_2_6# vdd vdd pfet w=40 l=2
+  ad=0.2n pd=90u as=0 ps=0
M2216 vdd AND2X2_9/B AND2X2_9/a_2_6# vdd pfet w=20 l=2
+  ad=0 pd=0 as=0 ps=0
M2217 gnd AND2X2_9/B AND2X2_9/a_9_6# Gnd nfet w=20 l=2
+  ad=0 pd=0 as=0 ps=0
M2218 gnd invader_1_coord_x[3] XOR2X1_20/a_2_6# Gnd nfet w=20 l=2
+  ad=70p pd=27u as=100p ps=50u
M2219 XOR2X1_20/Y XOR2X1_20/a_2_6# XOR2X1_20/a_18_6# Gnd nfet w=20 l=2
+  ad=100p pd=30u as=29.999998p ps=23u
M2220 XOR2X1_20/a_13_43# player_coord_x[3] gnd Gnd nfet w=20 l=2
+  ad=100p pd=50u as=70p ps=27u
M2221 XOR2X1_20/a_18_54# XOR2X1_20/a_13_43# vdd vdd pfet w=40 l=2
+  ad=59.999996p pd=43u as=0.14n ps=47u
M2222 XOR2X1_20/a_35_6# invader_1_coord_x[3] XOR2X1_20/Y Gnd nfet w=20 l=2
+  ad=29.999998p pd=23u as=100p ps=30u
M2223 XOR2X1_20/a_18_6# XOR2X1_20/a_13_43# gnd Gnd nfet w=20 l=2
+  ad=29.999998p pd=23u as=70p ps=27u
M2224 vdd invader_1_coord_x[3] XOR2X1_20/a_2_6# vdd pfet w=40 l=2
+  ad=0.14n pd=47u as=0.2n ps=90u
M2225 vdd player_coord_x[3] XOR2X1_20/a_35_54# vdd pfet w=40 l=2
+  ad=0.14n pd=47u as=59.999996p ps=43u
M2226 XOR2X1_20/Y invader_1_coord_x[3] XOR2X1_20/a_18_54# vdd pfet w=40 l=2
+  ad=0.2n pd=50u as=59.999996p ps=43u
M2227 XOR2X1_20/a_35_54# XOR2X1_20/a_2_6# XOR2X1_20/Y vdd pfet w=40 l=2
+  ad=59.999996p pd=43u as=0.2n ps=50u
M2228 XOR2X1_20/a_13_43# player_coord_x[3] vdd vdd pfet w=40 l=2
+  ad=0.2n pd=90u as=0.14n ps=47u
M2229 gnd player_coord_x[3] XOR2X1_20/a_35_6# Gnd nfet w=20 l=2
+  ad=70p pd=27u as=29.999998p ps=23u
M2230 gnd INVX2_67/Y AOI22X1_4/a_28_6# Gnd nfet w=20 l=2
+  ad=0 pd=0 as=59.999996p ps=46u
M2231 OR2X1_2/A INVX2_67/Y AOI22X1_4/a_11_6# Gnd nfet w=20 l=2
+  ad=0.2n pd=60u as=59.999996p ps=46u
M2232 AOI22X1_4/a_11_6# AOI22X1_4/A gnd Gnd nfet w=20 l=2
+  ad=0 pd=0 as=0 ps=0
M2233 AOI22X1_4/a_2_54# INVX2_67/Y vdd vdd pfet w=40 l=2
+  ad=0.64n pd=0.272m as=0 ps=0
M2234 AOI22X1_4/a_28_6# AOI22X1_4/D OR2X1_2/A Gnd nfet w=20 l=2
+  ad=0 pd=0 as=0 ps=0
M2235 vdd AOI22X1_4/A AOI22X1_4/a_2_54# vdd pfet w=40 l=2
+  ad=0 pd=0 as=0 ps=0
M2236 OR2X1_2/A AOI22X1_4/D AOI22X1_4/a_2_54# vdd pfet w=40 l=2
+  ad=0.24n pd=92u as=0 ps=0
M2237 AOI22X1_4/a_2_54# INVX2_67/Y OR2X1_2/A vdd pfet w=40 l=2
+  ad=0 pd=0 as=0 ps=0
M2238 gnd XNOR2X1_8/B OAI21X1_150/a_2_6# Gnd nfet w=20 l=2
+  ad=0 pd=0 as=0.22n ps=0.102m
M2239 vdd NAND2X1_79/Y NAND2X1_78/B vdd pfet w=20 l=2
+  ad=0 pd=0 as=0.22n ps=92u
M2240 NAND2X1_78/B NAND2X1_79/Y OAI21X1_150/a_2_6# Gnd nfet w=20 l=2
+  ad=100p pd=50u as=0 ps=0
M2241 NAND2X1_78/B XNOR2X1_8/A OAI21X1_150/a_9_54# vdd pfet w=40 l=2
+  ad=0 pd=0 as=0.12n ps=86u
M2242 OAI21X1_150/a_9_54# XNOR2X1_8/B vdd vdd pfet w=40 l=2
+  ad=0 pd=0 as=0 ps=0
M2243 OAI21X1_150/a_2_6# XNOR2X1_8/A gnd Gnd nfet w=20 l=2
+  ad=0 pd=0 as=0 ps=0
M2244 NAND3X1_41/A AOI22X1_9/Y vdd vdd pfet w=20 l=2
+  ad=0.12n pd=52u as=0 ps=0
M2245 NAND2X1_25/a_9_6# AOI22X1_9/Y gnd Gnd nfet w=20 l=2
+  ad=59.999996p pd=46u as=0 ps=0
M2246 vdd NOR2X1_13/Y NAND3X1_41/A vdd pfet w=20 l=2
+  ad=0 pd=0 as=0 ps=0
M2247 NAND3X1_41/A NOR2X1_13/Y NAND2X1_25/a_9_6# Gnd nfet w=20 l=2
+  ad=100p pd=50u as=0 ps=0
M2248 OAI21X1_7/C player_bullet_coord_y[3] vdd vdd pfet w=20 l=2
+  ad=0.12n pd=52u as=0 ps=0
M2249 NAND2X1_14/a_9_6# player_bullet_coord_y[3] gnd Gnd nfet w=20 l=2
+  ad=59.999996p pd=46u as=0 ps=0
M2250 vdd INVX2_39/Y OAI21X1_7/C vdd pfet w=20 l=2
+  ad=0 pd=0 as=0 ps=0
M2251 OAI21X1_7/C INVX2_39/Y NAND2X1_14/a_9_6# Gnd nfet w=20 l=2
+  ad=100p pd=50u as=0 ps=0
M2252 INVX2_132/A INVX2_89/Y vdd vdd pfet w=20 l=2
+  ad=0.12n pd=52u as=0 ps=0
M2253 NAND2X1_47/a_9_6# INVX2_89/Y gnd Gnd nfet w=20 l=2
+  ad=59.999996p pd=46u as=0 ps=0
M2254 vdd NAND2X1_1/B INVX2_132/A vdd pfet w=20 l=2
+  ad=0 pd=0 as=0 ps=0
M2255 INVX2_132/A NAND2X1_1/B NAND2X1_47/a_9_6# Gnd nfet w=20 l=2
+  ad=100p pd=50u as=0 ps=0
M2256 NAND2X1_58/Y OR2X1_17/Y vdd vdd pfet w=20 l=2
+  ad=0.12n pd=52u as=0 ps=0
M2257 NAND2X1_58/a_9_6# OR2X1_17/Y gnd Gnd nfet w=20 l=2
+  ad=59.999996p pd=46u as=0 ps=0
M2258 vdd INVX2_176/Y NAND2X1_58/Y vdd pfet w=20 l=2
+  ad=0 pd=0 as=0 ps=0
M2259 NAND2X1_58/Y INVX2_176/Y NAND2X1_58/a_9_6# Gnd nfet w=20 l=2
+  ad=100p pd=50u as=0 ps=0
M2260 NAND2X1_36/Y NAND2X1_36/A vdd vdd pfet w=20 l=2
+  ad=0.12n pd=52u as=0 ps=0
M2261 NAND2X1_36/a_9_6# NAND2X1_36/A gnd Gnd nfet w=20 l=2
+  ad=59.999996p pd=46u as=0 ps=0
M2262 vdd NAND2X1_36/B NAND2X1_36/Y vdd pfet w=20 l=2
+  ad=0 pd=0 as=0 ps=0
M2263 NAND2X1_36/Y NAND2X1_36/B NAND2X1_36/a_9_6# Gnd nfet w=20 l=2
+  ad=100p pd=50u as=0 ps=0
M2264 INVX2_108/A NAND2X1_69/A vdd vdd pfet w=20 l=2
+  ad=0.12n pd=52u as=0 ps=0
M2265 NAND2X1_69/a_9_6# NAND2X1_69/A gnd Gnd nfet w=20 l=2
+  ad=59.999996p pd=46u as=0 ps=0
M2266 vdd invader_2_display INVX2_108/A vdd pfet w=20 l=2
+  ad=0 pd=0 as=0 ps=0
M2267 INVX2_108/A invader_2_display NAND2X1_69/a_9_6# Gnd nfet w=20 l=2
+  ad=100p pd=50u as=0 ps=0
M2268 gnd AOI22X1_13/Y AOI22X1_12/a_28_6# Gnd nfet w=20 l=2
+  ad=0 pd=0 as=59.999996p ps=46u
M2269 NAND2X1_26/A INVX2_92/Y AOI22X1_12/a_11_6# Gnd nfet w=20 l=2
+  ad=0.2n pd=60u as=59.999996p ps=46u
M2270 AOI22X1_12/a_11_6# XOR2X1_1/Y gnd Gnd nfet w=20 l=2
+  ad=0 pd=0 as=0 ps=0
M2271 AOI22X1_12/a_2_54# INVX2_92/Y vdd vdd pfet w=40 l=2
+  ad=0.64n pd=0.272m as=0 ps=0
M2272 AOI22X1_12/a_28_6# OAI21X1_33/Y NAND2X1_26/A Gnd nfet w=20 l=2
+  ad=0 pd=0 as=0 ps=0
M2273 vdd XOR2X1_1/Y AOI22X1_12/a_2_54# vdd pfet w=40 l=2
+  ad=0 pd=0 as=0 ps=0
M2274 NAND2X1_26/A OAI21X1_33/Y AOI22X1_12/a_2_54# vdd pfet w=40 l=2
+  ad=0.24n pd=92u as=0 ps=0
M2275 AOI22X1_12/a_2_54# AOI22X1_13/Y NAND2X1_26/A vdd pfet w=40 l=2
+  ad=0 pd=0 as=0 ps=0
M2276 gnd player_bullet_coord_x[2] AOI22X1_23/a_28_6# Gnd nfet w=20 l=2
+  ad=0 pd=0 as=59.999996p ps=46u
M2277 INVX2_142/A NOR2X1_26/Y AOI22X1_23/a_11_6# Gnd nfet w=20 l=2
+  ad=0.2n pd=60u as=59.999996p ps=46u
M2278 AOI22X1_23/a_11_6# player_coord_x[2] gnd Gnd nfet w=20 l=2
+  ad=0 pd=0 as=0 ps=0
M2279 AOI22X1_23/a_2_54# NOR2X1_26/Y vdd vdd pfet w=40 l=2
+  ad=0.64n pd=0.272m as=0 ps=0
M2280 AOI22X1_23/a_28_6# AND2X2_0/A INVX2_142/A Gnd nfet w=20 l=2
+  ad=0 pd=0 as=0 ps=0
M2281 vdd player_coord_x[2] AOI22X1_23/a_2_54# vdd pfet w=40 l=2
+  ad=0 pd=0 as=0 ps=0
M2282 INVX2_142/A AND2X2_0/A AOI22X1_23/a_2_54# vdd pfet w=40 l=2
+  ad=0.24n pd=92u as=0 ps=0
M2283 AOI22X1_23/a_2_54# player_bullet_coord_x[2] INVX2_142/A vdd pfet w=40 l=2
+  ad=0 pd=0 as=0 ps=0
M2284 gnd INVX2_62/A AOI22X1_34/a_28_6# Gnd nfet w=20 l=2
+  ad=0 pd=0 as=59.999996p ps=46u
M2285 OAI21X1_80/C AND2X2_13/Y AOI22X1_34/a_11_6# Gnd nfet w=20 l=2
+  ad=0.2n pd=60u as=59.999996p ps=46u
M2286 AOI22X1_34/a_11_6# INVX2_63/Y gnd Gnd nfet w=20 l=2
+  ad=0 pd=0 as=0 ps=0
M2287 AOI22X1_34/a_2_54# AND2X2_13/Y vdd vdd pfet w=40 l=2
+  ad=0.64n pd=0.272m as=0 ps=0
M2288 AOI22X1_34/a_28_6# AND2X2_12/Y OAI21X1_80/C Gnd nfet w=20 l=2
+  ad=0 pd=0 as=0 ps=0
M2289 vdd INVX2_63/Y AOI22X1_34/a_2_54# vdd pfet w=40 l=2
+  ad=0 pd=0 as=0 ps=0
M2290 OAI21X1_80/C AND2X2_12/Y AOI22X1_34/a_2_54# vdd pfet w=40 l=2
+  ad=0.24n pd=92u as=0 ps=0
M2291 AOI22X1_34/a_2_54# INVX2_62/A OAI21X1_80/C vdd pfet w=40 l=2
+  ad=0 pd=0 as=0 ps=0
M2292 gnd OR2X1_5/Y AOI22X1_45/a_28_6# Gnd nfet w=20 l=2
+  ad=0 pd=0 as=59.999996p ps=46u
M2293 OR2X1_16/B AOI22X1_45/B AOI22X1_45/a_11_6# Gnd nfet w=20 l=2
+  ad=0.2n pd=60u as=59.999996p ps=46u
M2294 AOI22X1_45/a_11_6# OR2X1_4/Y gnd Gnd nfet w=20 l=2
+  ad=0 pd=0 as=0 ps=0
M2295 AOI22X1_45/a_2_54# AOI22X1_45/B vdd vdd pfet w=40 l=2
+  ad=0.64n pd=0.272m as=0 ps=0
M2296 AOI22X1_45/a_28_6# AOI22X1_45/D OR2X1_16/B Gnd nfet w=20 l=2
+  ad=0 pd=0 as=0 ps=0
M2297 vdd OR2X1_4/Y AOI22X1_45/a_2_54# vdd pfet w=40 l=2
+  ad=0 pd=0 as=0 ps=0
M2298 OR2X1_16/B AOI22X1_45/D AOI22X1_45/a_2_54# vdd pfet w=40 l=2
+  ad=0.24n pd=92u as=0 ps=0
M2299 AOI22X1_45/a_2_54# OR2X1_5/Y OR2X1_16/B vdd pfet w=40 l=2
+  ad=0 pd=0 as=0 ps=0
M2300 gnd XOR2X1_13/Y AOI22X1_56/a_28_6# Gnd nfet w=20 l=2
+  ad=0 pd=0 as=59.999996p ps=46u
M2301 NAND2X1_67/A XOR2X1_14/Y AOI22X1_56/a_11_6# Gnd nfet w=20 l=2
+  ad=0.2n pd=60u as=59.999996p ps=46u
M2302 AOI22X1_56/a_11_6# INVX2_106/Y gnd Gnd nfet w=20 l=2
+  ad=0 pd=0 as=0 ps=0
M2303 AOI22X1_56/a_2_54# XOR2X1_14/Y vdd vdd pfet w=40 l=2
+  ad=0.64n pd=0.272m as=0 ps=0
M2304 AOI22X1_56/a_28_6# INVX2_106/A NAND2X1_67/A Gnd nfet w=20 l=2
+  ad=0 pd=0 as=0 ps=0
M2305 vdd INVX2_106/Y AOI22X1_56/a_2_54# vdd pfet w=40 l=2
+  ad=0 pd=0 as=0 ps=0
M2306 NAND2X1_67/A INVX2_106/A AOI22X1_56/a_2_54# vdd pfet w=40 l=2
+  ad=0.24n pd=92u as=0 ps=0
M2307 AOI22X1_56/a_2_54# XOR2X1_13/Y NAND2X1_67/A vdd pfet w=40 l=2
+  ad=0 pd=0 as=0 ps=0
M2308 gnd OAI22X1_8/A OAI22X1_7/a_2_6# Gnd nfet w=20 l=2
+  ad=0 pd=0 as=0.32n ps=0.152m
M2309 OAI22X1_7/a_2_6# OAI22X1_7/C OAI22X1_7/Y Gnd nfet w=20 l=2
+  ad=0 pd=0 as=0.12n ps=52u
M2310 OAI22X1_7/Y OAI22X1_8/D OAI22X1_7/a_2_6# Gnd nfet w=20 l=2
+  ad=0 pd=0 as=0 ps=0
M2311 OAI22X1_7/Y OAI22X1_7/B OAI22X1_7/a_9_54# vdd pfet w=40 l=2
+  ad=0.48n pd=0.104m as=0.12n ps=86u
M2312 OAI22X1_7/a_28_54# OAI22X1_8/D OAI22X1_7/Y vdd pfet w=40 l=2
+  ad=0.12n pd=86u as=0 ps=0
M2313 OAI22X1_7/a_9_54# OAI22X1_8/A vdd vdd pfet w=40 l=2
+  ad=0 pd=0 as=0 ps=0
M2314 OAI22X1_7/a_2_6# OAI22X1_7/B gnd Gnd nfet w=20 l=2
+  ad=0 pd=0 as=0 ps=0
M2315 vdd OAI22X1_7/C OAI22X1_7/a_28_54# vdd pfet w=40 l=2
+  ad=0 pd=0 as=0 ps=0
M2316 INVX2_16/Y INVX2_16/A gnd Gnd nfet w=20 l=2
+  ad=100p pd=50u as=0 ps=0
M2317 INVX2_16/Y INVX2_16/A vdd vdd pfet w=40 l=2
+  ad=0.2n pd=90u as=0 ps=0
M2318 INVX2_27/Y INVX2_27/A gnd Gnd nfet w=20 l=2
+  ad=100p pd=50u as=0 ps=0
M2319 INVX2_27/Y INVX2_27/A vdd vdd pfet w=40 l=2
+  ad=0.2n pd=90u as=0 ps=0
M2320 INVX2_49/Y INVX2_49/A gnd Gnd nfet w=20 l=2
+  ad=100p pd=50u as=0 ps=0
M2321 INVX2_49/Y INVX2_49/A vdd vdd pfet w=40 l=2
+  ad=0.2n pd=90u as=0 ps=0
M2322 INVX2_38/Y invader_2_coord_y[3] gnd Gnd nfet w=20 l=2
+  ad=100p pd=50u as=0 ps=0
M2323 INVX2_38/Y invader_2_coord_y[3] vdd vdd pfet w=40 l=2
+  ad=0.2n pd=90u as=0 ps=0
M2324 INVX2_150/Y INVX2_150/A gnd Gnd nfet w=20 l=2
+  ad=100p pd=50u as=0 ps=0
M2325 INVX2_150/Y INVX2_150/A vdd vdd pfet w=40 l=2
+  ad=0.2n pd=90u as=0 ps=0
M2326 INVX2_161/Y INVX2_161/A gnd Gnd nfet w=20 l=2
+  ad=100p pd=50u as=0 ps=0
M2327 INVX2_161/Y INVX2_161/A vdd vdd pfet w=40 l=2
+  ad=0.2n pd=90u as=0 ps=0
M2328 INVX2_172/Y INVX2_172/A gnd Gnd nfet w=20 l=2
+  ad=100p pd=50u as=0 ps=0
M2329 INVX2_172/Y INVX2_172/A vdd vdd pfet w=40 l=2
+  ad=0.2n pd=90u as=0 ps=0
M2330 OR2X1_17/A player_coord_x[1] gnd Gnd nfet w=20 l=2
+  ad=100p pd=50u as=0 ps=0
M2331 OR2X1_17/A player_coord_x[1] vdd vdd pfet w=40 l=2
+  ad=0.2n pd=90u as=0 ps=0
M2332 DFFNEGX1_12/a_76_6# BUFX2_7/Y DFFNEGX1_12/a_66_6# Gnd nfet w=10 l=2
+  ad=29.999998p pd=26u as=80p ps=36u
M2333 gnd BUFX2_7/Y DFFNEGX1_12/a_2_6# Gnd nfet w=20 l=2
+  ad=0 pd=0 as=100p ps=50u
M2334 DFFNEGX1_12/a_66_6# DFFNEGX1_12/a_2_6# DFFNEGX1_12/a_61_6# Gnd nfet w=10 l=2
+  ad=0 pd=0 as=29.999998p ps=26u
M2335 player_bullet_coord_y[2] DFFNEGX1_12/a_66_6# gnd Gnd nfet w=20 l=2
+  ad=100p pd=50u as=0 ps=0
M2336 DFFNEGX1_12/a_23_6# BUFX2_7/Y DFFNEGX1_12/a_17_6# Gnd nfet w=10 l=2
+  ad=59.999996p pd=32u as=40p ps=28u
M2337 DFFNEGX1_12/a_23_6# DFFNEGX1_12/a_2_6# DFFNEGX1_12/a_17_74# vdd pfet w=20 l=2
+  ad=0.12n pd=52u as=80p ps=48u
M2338 gnd DFFNEGX1_12/a_34_4# DFFNEGX1_12/a_31_6# Gnd nfet w=10 l=2
+  ad=0 pd=0 as=29.999998p ps=26u
M2339 vdd DFFNEGX1_12/a_34_4# DFFNEGX1_12/a_31_74# vdd pfet w=20 l=2
+  ad=0 pd=0 as=80p ps=48u
M2340 DFFNEGX1_12/a_61_74# DFFNEGX1_12/a_34_4# vdd vdd pfet w=20 l=2
+  ad=59.999996p pd=46u as=0 ps=0
M2341 DFFNEGX1_12/a_34_4# DFFNEGX1_12/a_23_6# vdd vdd pfet w=20 l=2
+  ad=100p pd=50u as=0 ps=0
M2342 DFFNEGX1_12/a_34_4# DFFNEGX1_12/a_23_6# gnd Gnd nfet w=10 l=2
+  ad=50p pd=30u as=0 ps=0
M2343 vdd player_bullet_coord_y[2] DFFNEGX1_12/a_76_84# vdd pfet w=10 l=2
+  ad=0 pd=0 as=29.999998p ps=26u
M2344 gnd player_bullet_coord_y[2] DFFNEGX1_12/a_76_6# Gnd nfet w=10 l=2
+  ad=0 pd=0 as=0 ps=0
M2345 DFFNEGX1_12/a_61_6# DFFNEGX1_12/a_34_4# gnd Gnd nfet w=10 l=2
+  ad=0 pd=0 as=0 ps=0
M2346 DFFNEGX1_12/a_76_84# DFFNEGX1_12/a_2_6# DFFNEGX1_12/a_66_6# vdd pfet w=10 l=2
+  ad=0 pd=0 as=0.15n ps=56u
M2347 player_bullet_coord_y[2] DFFNEGX1_12/a_66_6# vdd vdd pfet w=40 l=2
+  ad=0.2n pd=90u as=0 ps=0
M2348 vdd BUFX2_7/Y DFFNEGX1_12/a_2_6# vdd pfet w=40 l=2
+  ad=0 pd=0 as=0.2n ps=90u
M2349 DFFNEGX1_12/a_31_6# DFFNEGX1_12/a_2_6# DFFNEGX1_12/a_23_6# Gnd nfet w=10 l=2
+  ad=0 pd=0 as=0 ps=0
M2350 DFFNEGX1_12/a_66_6# BUFX2_7/Y DFFNEGX1_12/a_61_74# vdd pfet w=20 l=2
+  ad=0 pd=0 as=0 ps=0
M2351 DFFNEGX1_12/a_17_74# AND2X2_0/Y vdd vdd pfet w=20 l=2
+  ad=0 pd=0 as=0 ps=0
M2352 DFFNEGX1_12/a_31_74# BUFX2_7/Y DFFNEGX1_12/a_23_6# vdd pfet w=20 l=2
+  ad=0 pd=0 as=0 ps=0
M2353 DFFNEGX1_12/a_17_6# AND2X2_0/Y gnd Gnd nfet w=10 l=2
+  ad=0 pd=0 as=0 ps=0
M2354 DFFNEGX1_34/a_76_6# BUFX2_5/Y DFFNEGX1_34/a_66_6# Gnd nfet w=10 l=2
+  ad=29.999998p pd=26u as=80p ps=36u
M2355 gnd BUFX2_5/Y DFFNEGX1_34/a_2_6# Gnd nfet w=20 l=2
+  ad=0 pd=0 as=100p ps=50u
M2356 DFFNEGX1_34/a_66_6# DFFNEGX1_34/a_2_6# DFFNEGX1_34/a_61_6# Gnd nfet w=10 l=2
+  ad=0 pd=0 as=29.999998p ps=26u
M2357 invader_2_coord_x[2] DFFNEGX1_34/a_66_6# gnd Gnd nfet w=20 l=2
+  ad=100p pd=50u as=0 ps=0
M2358 DFFNEGX1_34/a_23_6# BUFX2_5/Y DFFNEGX1_34/a_17_6# Gnd nfet w=10 l=2
+  ad=59.999996p pd=32u as=40p ps=28u
M2359 DFFNEGX1_34/a_23_6# DFFNEGX1_34/a_2_6# DFFNEGX1_34/a_17_74# vdd pfet w=20 l=2
+  ad=0.12n pd=52u as=80p ps=48u
M2360 gnd DFFNEGX1_34/a_34_4# DFFNEGX1_34/a_31_6# Gnd nfet w=10 l=2
+  ad=0 pd=0 as=29.999998p ps=26u
M2361 vdd DFFNEGX1_34/a_34_4# DFFNEGX1_34/a_31_74# vdd pfet w=20 l=2
+  ad=0 pd=0 as=80p ps=48u
M2362 DFFNEGX1_34/a_61_74# DFFNEGX1_34/a_34_4# vdd vdd pfet w=20 l=2
+  ad=59.999996p pd=46u as=0 ps=0
M2363 DFFNEGX1_34/a_34_4# DFFNEGX1_34/a_23_6# vdd vdd pfet w=20 l=2
+  ad=100p pd=50u as=0 ps=0
M2364 DFFNEGX1_34/a_34_4# DFFNEGX1_34/a_23_6# gnd Gnd nfet w=10 l=2
+  ad=50p pd=30u as=0 ps=0
M2365 vdd invader_2_coord_x[2] DFFNEGX1_34/a_76_84# vdd pfet w=10 l=2
+  ad=0 pd=0 as=29.999998p ps=26u
M2366 gnd invader_2_coord_x[2] DFFNEGX1_34/a_76_6# Gnd nfet w=10 l=2
+  ad=0 pd=0 as=0 ps=0
M2367 DFFNEGX1_34/a_61_6# DFFNEGX1_34/a_34_4# gnd Gnd nfet w=10 l=2
+  ad=0 pd=0 as=0 ps=0
M2368 DFFNEGX1_34/a_76_84# DFFNEGX1_34/a_2_6# DFFNEGX1_34/a_66_6# vdd pfet w=10 l=2
+  ad=0 pd=0 as=0.15n ps=56u
M2369 invader_2_coord_x[2] DFFNEGX1_34/a_66_6# vdd vdd pfet w=40 l=2
+  ad=0.2n pd=90u as=0 ps=0
M2370 vdd BUFX2_5/Y DFFNEGX1_34/a_2_6# vdd pfet w=40 l=2
+  ad=0 pd=0 as=0.2n ps=90u
M2371 DFFNEGX1_34/a_31_6# DFFNEGX1_34/a_2_6# DFFNEGX1_34/a_23_6# Gnd nfet w=10 l=2
+  ad=0 pd=0 as=0 ps=0
M2372 DFFNEGX1_34/a_66_6# BUFX2_5/Y DFFNEGX1_34/a_61_74# vdd pfet w=20 l=2
+  ad=0 pd=0 as=0 ps=0
M2373 DFFNEGX1_34/a_17_74# NAND2X1_36/Y vdd vdd pfet w=20 l=2
+  ad=0 pd=0 as=0 ps=0
M2374 DFFNEGX1_34/a_31_74# BUFX2_5/Y DFFNEGX1_34/a_23_6# vdd pfet w=20 l=2
+  ad=0 pd=0 as=0 ps=0
M2375 DFFNEGX1_34/a_17_6# NAND2X1_36/Y gnd Gnd nfet w=10 l=2
+  ad=0 pd=0 as=0 ps=0
M2376 DFFNEGX1_23/a_76_6# clka DFFNEGX1_23/a_66_6# Gnd nfet w=10 l=2
+  ad=29.999998p pd=26u as=80p ps=36u
M2377 gnd clka DFFNEGX1_23/a_2_6# Gnd nfet w=20 l=2
+  ad=0 pd=0 as=100p ps=50u
M2378 DFFNEGX1_23/a_66_6# DFFNEGX1_23/a_2_6# DFFNEGX1_23/a_61_6# Gnd nfet w=10 l=2
+  ad=0 pd=0 as=29.999998p ps=26u
M2379 INVX2_26/A DFFNEGX1_23/a_66_6# gnd Gnd nfet w=20 l=2
+  ad=100p pd=50u as=0 ps=0
M2380 DFFNEGX1_23/a_23_6# clka DFFNEGX1_23/a_17_6# Gnd nfet w=10 l=2
+  ad=59.999996p pd=32u as=40p ps=28u
M2381 DFFNEGX1_23/a_23_6# DFFNEGX1_23/a_2_6# DFFNEGX1_23/a_17_74# vdd pfet w=20 l=2
+  ad=0.12n pd=52u as=80p ps=48u
M2382 gnd DFFNEGX1_23/a_34_4# DFFNEGX1_23/a_31_6# Gnd nfet w=10 l=2
+  ad=0 pd=0 as=29.999998p ps=26u
M2383 vdd DFFNEGX1_23/a_34_4# DFFNEGX1_23/a_31_74# vdd pfet w=20 l=2
+  ad=0 pd=0 as=80p ps=48u
M2384 DFFNEGX1_23/a_61_74# DFFNEGX1_23/a_34_4# vdd vdd pfet w=20 l=2
+  ad=59.999996p pd=46u as=0 ps=0
M2385 DFFNEGX1_23/a_34_4# DFFNEGX1_23/a_23_6# vdd vdd pfet w=20 l=2
+  ad=100p pd=50u as=0 ps=0
M2386 DFFNEGX1_23/a_34_4# DFFNEGX1_23/a_23_6# gnd Gnd nfet w=10 l=2
+  ad=50p pd=30u as=0 ps=0
M2387 vdd INVX2_26/A DFFNEGX1_23/a_76_84# vdd pfet w=10 l=2
+  ad=0 pd=0 as=29.999998p ps=26u
M2388 gnd INVX2_26/A DFFNEGX1_23/a_76_6# Gnd nfet w=10 l=2
+  ad=0 pd=0 as=0 ps=0
M2389 DFFNEGX1_23/a_61_6# DFFNEGX1_23/a_34_4# gnd Gnd nfet w=10 l=2
+  ad=0 pd=0 as=0 ps=0
M2390 DFFNEGX1_23/a_76_84# DFFNEGX1_23/a_2_6# DFFNEGX1_23/a_66_6# vdd pfet w=10 l=2
+  ad=0 pd=0 as=0.15n ps=56u
M2391 INVX2_26/A DFFNEGX1_23/a_66_6# vdd vdd pfet w=40 l=2
+  ad=0.2n pd=90u as=0 ps=0
M2392 vdd clka DFFNEGX1_23/a_2_6# vdd pfet w=40 l=2
+  ad=0 pd=0 as=0.2n ps=90u
M2393 DFFNEGX1_23/a_31_6# DFFNEGX1_23/a_2_6# DFFNEGX1_23/a_23_6# Gnd nfet w=10 l=2
+  ad=0 pd=0 as=0 ps=0
M2394 DFFNEGX1_23/a_66_6# clka DFFNEGX1_23/a_61_74# vdd pfet w=20 l=2
+  ad=0 pd=0 as=0 ps=0
M2395 DFFNEGX1_23/a_17_74# OAI21X1_71/Y vdd vdd pfet w=20 l=2
+  ad=0 pd=0 as=0 ps=0
M2396 DFFNEGX1_23/a_31_74# clka DFFNEGX1_23/a_23_6# vdd pfet w=20 l=2
+  ad=0 pd=0 as=0 ps=0
M2397 DFFNEGX1_23/a_17_6# OAI21X1_71/Y gnd Gnd nfet w=10 l=2
+  ad=0 pd=0 as=0 ps=0
M2398 DFFNEGX1_56/a_76_6# clka DFFNEGX1_56/a_66_6# Gnd nfet w=10 l=2
+  ad=29.999998p pd=26u as=80p ps=36u
M2399 gnd clka DFFNEGX1_56/a_2_6# Gnd nfet w=20 l=2
+  ad=0 pd=0 as=100p ps=50u
M2400 DFFNEGX1_56/a_66_6# DFFNEGX1_56/a_2_6# DFFNEGX1_56/a_61_6# Gnd nfet w=10 l=2
+  ad=0 pd=0 as=29.999998p ps=26u
M2401 AND2X2_18/B DFFNEGX1_56/a_66_6# gnd Gnd nfet w=20 l=2
+  ad=100p pd=50u as=0 ps=0
M2402 DFFNEGX1_56/a_23_6# clka DFFNEGX1_56/a_17_6# Gnd nfet w=10 l=2
+  ad=59.999996p pd=32u as=40p ps=28u
M2403 DFFNEGX1_56/a_23_6# DFFNEGX1_56/a_2_6# DFFNEGX1_56/a_17_74# vdd pfet w=20 l=2
+  ad=0.12n pd=52u as=80p ps=48u
M2404 gnd DFFNEGX1_56/a_34_4# DFFNEGX1_56/a_31_6# Gnd nfet w=10 l=2
+  ad=0 pd=0 as=29.999998p ps=26u
M2405 vdd DFFNEGX1_56/a_34_4# DFFNEGX1_56/a_31_74# vdd pfet w=20 l=2
+  ad=0 pd=0 as=80p ps=48u
M2406 DFFNEGX1_56/a_61_74# DFFNEGX1_56/a_34_4# vdd vdd pfet w=20 l=2
+  ad=59.999996p pd=46u as=0 ps=0
M2407 DFFNEGX1_56/a_34_4# DFFNEGX1_56/a_23_6# vdd vdd pfet w=20 l=2
+  ad=100p pd=50u as=0 ps=0
M2408 DFFNEGX1_56/a_34_4# DFFNEGX1_56/a_23_6# gnd Gnd nfet w=10 l=2
+  ad=50p pd=30u as=0 ps=0
M2409 vdd AND2X2_18/B DFFNEGX1_56/a_76_84# vdd pfet w=10 l=2
+  ad=0 pd=0 as=29.999998p ps=26u
M2410 gnd AND2X2_18/B DFFNEGX1_56/a_76_6# Gnd nfet w=10 l=2
+  ad=0 pd=0 as=0 ps=0
M2411 DFFNEGX1_56/a_61_6# DFFNEGX1_56/a_34_4# gnd Gnd nfet w=10 l=2
+  ad=0 pd=0 as=0 ps=0
M2412 DFFNEGX1_56/a_76_84# DFFNEGX1_56/a_2_6# DFFNEGX1_56/a_66_6# vdd pfet w=10 l=2
+  ad=0 pd=0 as=0.15n ps=56u
M2413 AND2X2_18/B DFFNEGX1_56/a_66_6# vdd vdd pfet w=40 l=2
+  ad=0.2n pd=90u as=0 ps=0
M2414 vdd clka DFFNEGX1_56/a_2_6# vdd pfet w=40 l=2
+  ad=0 pd=0 as=0.2n ps=90u
M2415 DFFNEGX1_56/a_31_6# DFFNEGX1_56/a_2_6# DFFNEGX1_56/a_23_6# Gnd nfet w=10 l=2
+  ad=0 pd=0 as=0 ps=0
M2416 DFFNEGX1_56/a_66_6# clka DFFNEGX1_56/a_61_74# vdd pfet w=20 l=2
+  ad=0 pd=0 as=0 ps=0
M2417 DFFNEGX1_56/a_17_74# NOR2X1_42/Y vdd vdd pfet w=20 l=2
+  ad=0 pd=0 as=0 ps=0
M2418 DFFNEGX1_56/a_31_74# clka DFFNEGX1_56/a_23_6# vdd pfet w=20 l=2
+  ad=0 pd=0 as=0 ps=0
M2419 DFFNEGX1_56/a_17_6# NOR2X1_42/Y gnd Gnd nfet w=10 l=2
+  ad=0 pd=0 as=0 ps=0
M2420 DFFNEGX1_67/a_76_6# BUFX2_3/Y DFFNEGX1_67/a_66_6# Gnd nfet w=10 l=2
+  ad=29.999998p pd=26u as=80p ps=36u
M2421 gnd BUFX2_3/Y DFFNEGX1_67/a_2_6# Gnd nfet w=20 l=2
+  ad=0 pd=0 as=100p ps=50u
M2422 DFFNEGX1_67/a_66_6# DFFNEGX1_67/a_2_6# DFFNEGX1_67/a_61_6# Gnd nfet w=10 l=2
+  ad=0 pd=0 as=29.999998p ps=26u
M2423 INVX2_96/A DFFNEGX1_67/a_66_6# gnd Gnd nfet w=20 l=2
+  ad=100p pd=50u as=0 ps=0
M2424 DFFNEGX1_67/a_23_6# BUFX2_3/Y DFFNEGX1_67/a_17_6# Gnd nfet w=10 l=2
+  ad=59.999996p pd=32u as=40p ps=28u
M2425 DFFNEGX1_67/a_23_6# DFFNEGX1_67/a_2_6# DFFNEGX1_67/a_17_74# vdd pfet w=20 l=2
+  ad=0.12n pd=52u as=80p ps=48u
M2426 gnd DFFNEGX1_67/a_34_4# DFFNEGX1_67/a_31_6# Gnd nfet w=10 l=2
+  ad=0 pd=0 as=29.999998p ps=26u
M2427 vdd DFFNEGX1_67/a_34_4# DFFNEGX1_67/a_31_74# vdd pfet w=20 l=2
+  ad=0 pd=0 as=80p ps=48u
M2428 DFFNEGX1_67/a_61_74# DFFNEGX1_67/a_34_4# vdd vdd pfet w=20 l=2
+  ad=59.999996p pd=46u as=0 ps=0
M2429 DFFNEGX1_67/a_34_4# DFFNEGX1_67/a_23_6# vdd vdd pfet w=20 l=2
+  ad=100p pd=50u as=0 ps=0
M2430 DFFNEGX1_67/a_34_4# DFFNEGX1_67/a_23_6# gnd Gnd nfet w=10 l=2
+  ad=50p pd=30u as=0 ps=0
M2431 vdd INVX2_96/A DFFNEGX1_67/a_76_84# vdd pfet w=10 l=2
+  ad=0 pd=0 as=29.999998p ps=26u
M2432 gnd INVX2_96/A DFFNEGX1_67/a_76_6# Gnd nfet w=10 l=2
+  ad=0 pd=0 as=0 ps=0
M2433 DFFNEGX1_67/a_61_6# DFFNEGX1_67/a_34_4# gnd Gnd nfet w=10 l=2
+  ad=0 pd=0 as=0 ps=0
M2434 DFFNEGX1_67/a_76_84# DFFNEGX1_67/a_2_6# DFFNEGX1_67/a_66_6# vdd pfet w=10 l=2
+  ad=0 pd=0 as=0.15n ps=56u
M2435 INVX2_96/A DFFNEGX1_67/a_66_6# vdd vdd pfet w=40 l=2
+  ad=0.2n pd=90u as=0 ps=0
M2436 vdd BUFX2_3/Y DFFNEGX1_67/a_2_6# vdd pfet w=40 l=2
+  ad=0 pd=0 as=0.2n ps=90u
M2437 DFFNEGX1_67/a_31_6# DFFNEGX1_67/a_2_6# DFFNEGX1_67/a_23_6# Gnd nfet w=10 l=2
+  ad=0 pd=0 as=0 ps=0
M2438 DFFNEGX1_67/a_66_6# BUFX2_3/Y DFFNEGX1_67/a_61_74# vdd pfet w=20 l=2
+  ad=0 pd=0 as=0 ps=0
M2439 DFFNEGX1_67/a_17_74# NOR2X1_48/Y vdd vdd pfet w=20 l=2
+  ad=0 pd=0 as=0 ps=0
M2440 DFFNEGX1_67/a_31_74# BUFX2_3/Y DFFNEGX1_67/a_23_6# vdd pfet w=20 l=2
+  ad=0 pd=0 as=0 ps=0
M2441 DFFNEGX1_67/a_17_6# NOR2X1_48/Y gnd Gnd nfet w=10 l=2
+  ad=0 pd=0 as=0 ps=0
M2442 DFFNEGX1_45/a_76_6# BUFX2_4/Y DFFNEGX1_45/a_66_6# Gnd nfet w=10 l=2
+  ad=29.999998p pd=26u as=80p ps=36u
M2443 gnd BUFX2_4/Y DFFNEGX1_45/a_2_6# Gnd nfet w=20 l=2
+  ad=0 pd=0 as=100p ps=50u
M2444 DFFNEGX1_45/a_66_6# DFFNEGX1_45/a_2_6# DFFNEGX1_45/a_61_6# Gnd nfet w=10 l=2
+  ad=0 pd=0 as=29.999998p ps=26u
M2445 INVX2_61/A DFFNEGX1_45/a_66_6# gnd Gnd nfet w=20 l=2
+  ad=100p pd=50u as=0 ps=0
M2446 DFFNEGX1_45/a_23_6# BUFX2_4/Y DFFNEGX1_45/a_17_6# Gnd nfet w=10 l=2
+  ad=59.999996p pd=32u as=40p ps=28u
M2447 DFFNEGX1_45/a_23_6# DFFNEGX1_45/a_2_6# DFFNEGX1_45/a_17_74# vdd pfet w=20 l=2
+  ad=0.12n pd=52u as=80p ps=48u
M2448 gnd DFFNEGX1_45/a_34_4# DFFNEGX1_45/a_31_6# Gnd nfet w=10 l=2
+  ad=0 pd=0 as=29.999998p ps=26u
M2449 vdd DFFNEGX1_45/a_34_4# DFFNEGX1_45/a_31_74# vdd pfet w=20 l=2
+  ad=0 pd=0 as=80p ps=48u
M2450 DFFNEGX1_45/a_61_74# DFFNEGX1_45/a_34_4# vdd vdd pfet w=20 l=2
+  ad=59.999996p pd=46u as=0 ps=0
M2451 DFFNEGX1_45/a_34_4# DFFNEGX1_45/a_23_6# vdd vdd pfet w=20 l=2
+  ad=100p pd=50u as=0 ps=0
M2452 DFFNEGX1_45/a_34_4# DFFNEGX1_45/a_23_6# gnd Gnd nfet w=10 l=2
+  ad=50p pd=30u as=0 ps=0
M2453 vdd INVX2_61/A DFFNEGX1_45/a_76_84# vdd pfet w=10 l=2
+  ad=0 pd=0 as=29.999998p ps=26u
M2454 gnd INVX2_61/A DFFNEGX1_45/a_76_6# Gnd nfet w=10 l=2
+  ad=0 pd=0 as=0 ps=0
M2455 DFFNEGX1_45/a_61_6# DFFNEGX1_45/a_34_4# gnd Gnd nfet w=10 l=2
+  ad=0 pd=0 as=0 ps=0
M2456 DFFNEGX1_45/a_76_84# DFFNEGX1_45/a_2_6# DFFNEGX1_45/a_66_6# vdd pfet w=10 l=2
+  ad=0 pd=0 as=0.15n ps=56u
M2457 INVX2_61/A DFFNEGX1_45/a_66_6# vdd vdd pfet w=40 l=2
+  ad=0.2n pd=90u as=0 ps=0
M2458 vdd BUFX2_4/Y DFFNEGX1_45/a_2_6# vdd pfet w=40 l=2
+  ad=0 pd=0 as=0.2n ps=90u
M2459 DFFNEGX1_45/a_31_6# DFFNEGX1_45/a_2_6# DFFNEGX1_45/a_23_6# Gnd nfet w=10 l=2
+  ad=0 pd=0 as=0 ps=0
M2460 DFFNEGX1_45/a_66_6# BUFX2_4/Y DFFNEGX1_45/a_61_74# vdd pfet w=20 l=2
+  ad=0 pd=0 as=0 ps=0
M2461 DFFNEGX1_45/a_17_74# OAI22X1_5/Y vdd vdd pfet w=20 l=2
+  ad=0 pd=0 as=0 ps=0
M2462 DFFNEGX1_45/a_31_74# BUFX2_4/Y DFFNEGX1_45/a_23_6# vdd pfet w=20 l=2
+  ad=0 pd=0 as=0 ps=0
M2463 DFFNEGX1_45/a_17_6# OAI22X1_5/Y gnd Gnd nfet w=10 l=2
+  ad=0 pd=0 as=0 ps=0
M2464 DFFNEGX1_78/a_76_6# BUFX2_2/Y DFFNEGX1_78/a_66_6# Gnd nfet w=10 l=2
+  ad=29.999998p pd=26u as=80p ps=36u
M2465 gnd BUFX2_2/Y DFFNEGX1_78/a_2_6# Gnd nfet w=20 l=2
+  ad=0 pd=0 as=100p ps=50u
M2466 DFFNEGX1_78/a_66_6# DFFNEGX1_78/a_2_6# DFFNEGX1_78/a_61_6# Gnd nfet w=10 l=2
+  ad=0 pd=0 as=29.999998p ps=26u
M2467 INVX2_126/A DFFNEGX1_78/a_66_6# gnd Gnd nfet w=20 l=2
+  ad=100p pd=50u as=0 ps=0
M2468 DFFNEGX1_78/a_23_6# BUFX2_2/Y DFFNEGX1_78/a_17_6# Gnd nfet w=10 l=2
+  ad=59.999996p pd=32u as=40p ps=28u
M2469 DFFNEGX1_78/a_23_6# DFFNEGX1_78/a_2_6# DFFNEGX1_78/a_17_74# vdd pfet w=20 l=2
+  ad=0.12n pd=52u as=80p ps=48u
M2470 gnd DFFNEGX1_78/a_34_4# DFFNEGX1_78/a_31_6# Gnd nfet w=10 l=2
+  ad=0 pd=0 as=29.999998p ps=26u
M2471 vdd DFFNEGX1_78/a_34_4# DFFNEGX1_78/a_31_74# vdd pfet w=20 l=2
+  ad=0 pd=0 as=80p ps=48u
M2472 DFFNEGX1_78/a_61_74# DFFNEGX1_78/a_34_4# vdd vdd pfet w=20 l=2
+  ad=59.999996p pd=46u as=0 ps=0
M2473 DFFNEGX1_78/a_34_4# DFFNEGX1_78/a_23_6# vdd vdd pfet w=20 l=2
+  ad=100p pd=50u as=0 ps=0
M2474 DFFNEGX1_78/a_34_4# DFFNEGX1_78/a_23_6# gnd Gnd nfet w=10 l=2
+  ad=50p pd=30u as=0 ps=0
M2475 vdd INVX2_126/A DFFNEGX1_78/a_76_84# vdd pfet w=10 l=2
+  ad=0 pd=0 as=29.999998p ps=26u
M2476 gnd INVX2_126/A DFFNEGX1_78/a_76_6# Gnd nfet w=10 l=2
+  ad=0 pd=0 as=0 ps=0
M2477 DFFNEGX1_78/a_61_6# DFFNEGX1_78/a_34_4# gnd Gnd nfet w=10 l=2
+  ad=0 pd=0 as=0 ps=0
M2478 DFFNEGX1_78/a_76_84# DFFNEGX1_78/a_2_6# DFFNEGX1_78/a_66_6# vdd pfet w=10 l=2
+  ad=0 pd=0 as=0.15n ps=56u
M2479 INVX2_126/A DFFNEGX1_78/a_66_6# vdd vdd pfet w=40 l=2
+  ad=0.2n pd=90u as=0 ps=0
M2480 vdd BUFX2_2/Y DFFNEGX1_78/a_2_6# vdd pfet w=40 l=2
+  ad=0 pd=0 as=0.2n ps=90u
M2481 DFFNEGX1_78/a_31_6# DFFNEGX1_78/a_2_6# DFFNEGX1_78/a_23_6# Gnd nfet w=10 l=2
+  ad=0 pd=0 as=0 ps=0
M2482 DFFNEGX1_78/a_66_6# BUFX2_2/Y DFFNEGX1_78/a_61_74# vdd pfet w=20 l=2
+  ad=0 pd=0 as=0 ps=0
M2483 DFFNEGX1_78/a_17_74# INVX2_172/Y vdd vdd pfet w=20 l=2
+  ad=0 pd=0 as=0 ps=0
M2484 DFFNEGX1_78/a_31_74# BUFX2_2/Y DFFNEGX1_78/a_23_6# vdd pfet w=20 l=2
+  ad=0 pd=0 as=0 ps=0
M2485 DFFNEGX1_78/a_17_6# INVX2_172/Y gnd Gnd nfet w=10 l=2
+  ad=0 pd=0 as=0 ps=0
M2486 DFFNEGX1_89/a_76_6# BUFX2_2/Y DFFNEGX1_89/a_66_6# Gnd nfet w=10 l=2
+  ad=29.999998p pd=26u as=80p ps=36u
M2487 gnd BUFX2_2/Y DFFNEGX1_89/a_2_6# Gnd nfet w=20 l=2
+  ad=0 pd=0 as=100p ps=50u
M2488 DFFNEGX1_89/a_66_6# DFFNEGX1_89/a_2_6# DFFNEGX1_89/a_61_6# Gnd nfet w=10 l=2
+  ad=0 pd=0 as=29.999998p ps=26u
M2489 INVX2_158/A DFFNEGX1_89/a_66_6# gnd Gnd nfet w=20 l=2
+  ad=100p pd=50u as=0 ps=0
M2490 DFFNEGX1_89/a_23_6# BUFX2_2/Y DFFNEGX1_89/a_17_6# Gnd nfet w=10 l=2
+  ad=59.999996p pd=32u as=40p ps=28u
M2491 DFFNEGX1_89/a_23_6# DFFNEGX1_89/a_2_6# DFFNEGX1_89/a_17_74# vdd pfet w=20 l=2
+  ad=0.12n pd=52u as=80p ps=48u
M2492 gnd DFFNEGX1_89/a_34_4# DFFNEGX1_89/a_31_6# Gnd nfet w=10 l=2
+  ad=0 pd=0 as=29.999998p ps=26u
M2493 vdd DFFNEGX1_89/a_34_4# DFFNEGX1_89/a_31_74# vdd pfet w=20 l=2
+  ad=0 pd=0 as=80p ps=48u
M2494 DFFNEGX1_89/a_61_74# DFFNEGX1_89/a_34_4# vdd vdd pfet w=20 l=2
+  ad=59.999996p pd=46u as=0 ps=0
M2495 DFFNEGX1_89/a_34_4# DFFNEGX1_89/a_23_6# vdd vdd pfet w=20 l=2
+  ad=100p pd=50u as=0 ps=0
M2496 DFFNEGX1_89/a_34_4# DFFNEGX1_89/a_23_6# gnd Gnd nfet w=10 l=2
+  ad=50p pd=30u as=0 ps=0
M2497 vdd INVX2_158/A DFFNEGX1_89/a_76_84# vdd pfet w=10 l=2
+  ad=0 pd=0 as=29.999998p ps=26u
M2498 gnd INVX2_158/A DFFNEGX1_89/a_76_6# Gnd nfet w=10 l=2
+  ad=0 pd=0 as=0 ps=0
M2499 DFFNEGX1_89/a_61_6# DFFNEGX1_89/a_34_4# gnd Gnd nfet w=10 l=2
+  ad=0 pd=0 as=0 ps=0
M2500 DFFNEGX1_89/a_76_84# DFFNEGX1_89/a_2_6# DFFNEGX1_89/a_66_6# vdd pfet w=10 l=2
+  ad=0 pd=0 as=0.15n ps=56u
M2501 INVX2_158/A DFFNEGX1_89/a_66_6# vdd vdd pfet w=40 l=2
+  ad=0.2n pd=90u as=0 ps=0
M2502 vdd BUFX2_2/Y DFFNEGX1_89/a_2_6# vdd pfet w=40 l=2
+  ad=0 pd=0 as=0.2n ps=90u
M2503 DFFNEGX1_89/a_31_6# DFFNEGX1_89/a_2_6# DFFNEGX1_89/a_23_6# Gnd nfet w=10 l=2
+  ad=0 pd=0 as=0 ps=0
M2504 DFFNEGX1_89/a_66_6# BUFX2_2/Y DFFNEGX1_89/a_61_74# vdd pfet w=20 l=2
+  ad=0 pd=0 as=0 ps=0
M2505 DFFNEGX1_89/a_17_74# INVX2_171/Y vdd vdd pfet w=20 l=2
+  ad=0 pd=0 as=0 ps=0
M2506 DFFNEGX1_89/a_31_74# BUFX2_2/Y DFFNEGX1_89/a_23_6# vdd pfet w=20 l=2
+  ad=0 pd=0 as=0 ps=0
M2507 DFFNEGX1_89/a_17_6# INVX2_171/Y gnd Gnd nfet w=10 l=2
+  ad=0 pd=0 as=0 ps=0
M2508 gnd INVX2_90/Y XOR2X1_10/a_2_6# Gnd nfet w=20 l=2
+  ad=0 pd=0 as=100p ps=50u
M2509 XOR2X1_10/Y XOR2X1_10/a_2_6# XOR2X1_10/a_18_6# Gnd nfet w=20 l=2
+  ad=0.2n pd=60u as=59.999996p ps=46u
M2510 XOR2X1_10/a_13_43# player_bullet_coord_y[2] gnd Gnd nfet w=20 l=2
+  ad=100p pd=50u as=0 ps=0
M2511 XOR2X1_10/a_18_54# XOR2X1_10/a_13_43# vdd vdd pfet w=40 l=2
+  ad=0.12n pd=86u as=0 ps=0
M2512 XOR2X1_10/a_35_6# INVX2_90/Y XOR2X1_10/Y Gnd nfet w=20 l=2
+  ad=59.999996p pd=46u as=0 ps=0
M2513 XOR2X1_10/a_18_6# XOR2X1_10/a_13_43# gnd Gnd nfet w=20 l=2
+  ad=0 pd=0 as=0 ps=0
M2514 vdd INVX2_90/Y XOR2X1_10/a_2_6# vdd pfet w=40 l=2
+  ad=0 pd=0 as=0.2n ps=90u
M2515 vdd player_bullet_coord_y[2] XOR2X1_10/a_35_54# vdd pfet w=40 l=2
+  ad=0 pd=0 as=0.12n ps=86u
M2516 XOR2X1_10/Y INVX2_90/Y XOR2X1_10/a_18_54# vdd pfet w=40 l=2
+  ad=0.4n pd=100u as=0 ps=0
M2517 XOR2X1_10/a_35_54# XOR2X1_10/a_2_6# XOR2X1_10/Y vdd pfet w=40 l=2
+  ad=0 pd=0 as=0 ps=0
M2518 XOR2X1_10/a_13_43# player_bullet_coord_y[2] vdd vdd pfet w=40 l=2
+  ad=0.2n pd=90u as=0 ps=0
M2519 gnd player_bullet_coord_y[2] XOR2X1_10/a_35_6# Gnd nfet w=20 l=2
+  ad=0 pd=0 as=0 ps=0
M2520 OAI21X1_2/C OAI21X1_1/C vdd vdd pfet w=20 l=2
+  ad=59.999996p pd=26u as=100p ps=50u
M2521 NAND3X1_0/a_9_6# OAI21X1_1/C gnd Gnd nfet w=30 l=2
+  ad=45p pd=33u as=0.15n ps=70u
M2522 OAI21X1_2/C HAX1_16/YS vdd vdd pfet w=20 l=2
+  ad=100p pd=50u as=59.999996p ps=26u
M2523 OAI21X1_2/C HAX1_16/YS NAND3X1_0/a_14_6# Gnd nfet w=30 l=2
+  ad=0.15n pd=70u as=45p ps=33u
M2524 vdd INVX2_19/Y OAI21X1_2/C vdd pfet w=20 l=2
+  ad=59.999996p pd=26u as=59.999996p ps=26u
M2525 NAND3X1_0/a_14_6# INVX2_19/Y NAND3X1_0/a_9_6# Gnd nfet w=30 l=2
+  ad=45p pd=33u as=45p ps=33u
M2526 gnd OAI22X1_7/B OAI21X1_140/a_2_6# Gnd nfet w=20 l=2
+  ad=0 pd=0 as=0.22n ps=0.102m
M2527 vdd player_coord_x[1] OAI21X1_140/Y vdd pfet w=20 l=2
+  ad=0 pd=0 as=0.22n ps=92u
M2528 OAI21X1_140/Y player_coord_x[1] OAI21X1_140/a_2_6# Gnd nfet w=20 l=2
+  ad=100p pd=50u as=0 ps=0
M2529 OAI21X1_140/Y INVX2_101/A OAI21X1_140/a_9_54# vdd pfet w=40 l=2
+  ad=0 pd=0 as=0.12n ps=86u
M2530 OAI21X1_140/a_9_54# OAI22X1_7/B vdd vdd pfet w=40 l=2
+  ad=0 pd=0 as=0 ps=0
M2531 OAI21X1_140/a_2_6# INVX2_101/A gnd Gnd nfet w=20 l=2
+  ad=0 pd=0 as=0 ps=0
M2532 gnd player_bullet_coord_x[1] AOI22X1_5/a_28_6# Gnd nfet w=20 l=2
+  ad=0 pd=0 as=59.999996p ps=46u
M2533 AOI22X1_5/Y invader_1_coord_x[0] AOI22X1_5/a_11_6# Gnd nfet w=20 l=2
+  ad=0.2n pd=60u as=59.999996p ps=46u
M2534 AOI22X1_5/a_11_6# player_bullet_coord_x[0] gnd Gnd nfet w=20 l=2
+  ad=0 pd=0 as=0 ps=0
M2535 AOI22X1_5/a_2_54# invader_1_coord_x[0] vdd vdd pfet w=40 l=2
+  ad=0.64n pd=0.272m as=0 ps=0
M2536 AOI22X1_5/a_28_6# INVX2_62/Y AOI22X1_5/Y Gnd nfet w=20 l=2
+  ad=0 pd=0 as=0 ps=0
M2537 vdd player_bullet_coord_x[0] AOI22X1_5/a_2_54# vdd pfet w=40 l=2
+  ad=0 pd=0 as=0 ps=0
M2538 AOI22X1_5/Y INVX2_62/Y AOI22X1_5/a_2_54# vdd pfet w=40 l=2
+  ad=0.24n pd=92u as=0 ps=0
M2539 AOI22X1_5/a_2_54# player_bullet_coord_x[1] AOI22X1_5/Y vdd pfet w=40 l=2
+  ad=0 pd=0 as=0 ps=0
M2540 gnd player_coord_x[2] OAI21X1_151/a_2_6# Gnd nfet w=20 l=2
+  ad=0 pd=0 as=0.22n ps=0.102m
M2541 vdd NAND2X1_79/Y XNOR2X1_8/B vdd pfet w=20 l=2
+  ad=0 pd=0 as=0.22n ps=92u
M2542 XNOR2X1_8/B NAND2X1_79/Y OAI21X1_151/a_2_6# Gnd nfet w=20 l=2
+  ad=100p pd=50u as=0 ps=0
M2543 XNOR2X1_8/B INVX2_64/Y OAI21X1_151/a_9_54# vdd pfet w=40 l=2
+  ad=0 pd=0 as=0.12n ps=86u
M2544 OAI21X1_151/a_9_54# player_coord_x[2] vdd vdd pfet w=40 l=2
+  ad=0 pd=0 as=0 ps=0
M2545 OAI21X1_151/a_2_6# INVX2_64/Y gnd Gnd nfet w=20 l=2
+  ad=0 pd=0 as=0 ps=0
M2546 NOR2X1_7/A NOR2X1_8/Y vdd vdd pfet w=20 l=2
+  ad=0.12n pd=52u as=0 ps=0
M2547 NAND2X1_15/a_9_6# NOR2X1_8/Y gnd Gnd nfet w=20 l=2
+  ad=59.999996p pd=46u as=0 ps=0
M2548 vdd INVX2_36/Y NOR2X1_7/A vdd pfet w=20 l=2
+  ad=0 pd=0 as=0 ps=0
M2549 NOR2X1_7/A INVX2_36/Y NAND2X1_15/a_9_6# Gnd nfet w=20 l=2
+  ad=100p pd=50u as=0 ps=0
M2550 NAND2X1_48/Y NAND2X1_48/A vdd vdd pfet w=20 l=2
+  ad=0.12n pd=52u as=0 ps=0
M2551 NAND2X1_48/a_9_6# NAND2X1_48/A gnd Gnd nfet w=20 l=2
+  ad=59.999996p pd=46u as=0 ps=0
M2552 vdd INVX2_133/Y NAND2X1_48/Y vdd pfet w=20 l=2
+  ad=0 pd=0 as=0 ps=0
M2553 NAND2X1_48/Y INVX2_133/Y NAND2X1_48/a_9_6# Gnd nfet w=20 l=2
+  ad=100p pd=50u as=0 ps=0
M2554 AND2X2_16/B NAND2X1_26/A vdd vdd pfet w=20 l=2
+  ad=0.12n pd=52u as=0 ps=0
M2555 NAND2X1_26/a_9_6# NAND2X1_26/A gnd Gnd nfet w=20 l=2
+  ad=59.999996p pd=46u as=0 ps=0
M2556 vdd NOR2X1_14/Y AND2X2_16/B vdd pfet w=20 l=2
+  ad=0 pd=0 as=0 ps=0
M2557 AND2X2_16/B NOR2X1_14/Y NAND2X1_26/a_9_6# Gnd nfet w=20 l=2
+  ad=100p pd=50u as=0 ps=0
M2558 NAND2X1_59/Y NAND2X1_60/Y vdd vdd pfet w=20 l=2
+  ad=0.12n pd=52u as=0 ps=0
M2559 NAND2X1_59/a_9_6# NAND2X1_60/Y gnd Gnd nfet w=20 l=2
+  ad=59.999996p pd=46u as=0 ps=0
M2560 vdd INVX2_7/Y NAND2X1_59/Y vdd pfet w=20 l=2
+  ad=0 pd=0 as=0 ps=0
M2561 NAND2X1_59/Y INVX2_7/Y NAND2X1_59/a_9_6# Gnd nfet w=20 l=2
+  ad=100p pd=50u as=0 ps=0
M2562 OAI22X1_4/B NOR2X1_31/Y vdd vdd pfet w=20 l=2
+  ad=0.12n pd=52u as=0 ps=0
M2563 NAND2X1_37/a_9_6# NOR2X1_31/Y gnd Gnd nfet w=20 l=2
+  ad=59.999996p pd=46u as=0 ps=0
M2564 vdd INVX2_29/Y OAI22X1_4/B vdd pfet w=20 l=2
+  ad=0 pd=0 as=0 ps=0
M2565 OAI22X1_4/B INVX2_29/Y NAND2X1_37/a_9_6# Gnd nfet w=20 l=2
+  ad=100p pd=50u as=0 ps=0
M2566 gnd shield_coord_x[1] AOI22X1_13/a_28_6# Gnd nfet w=20 l=2
+  ad=0 pd=0 as=59.999996p ps=46u
M2567 AOI22X1_13/Y INVX2_20/Y AOI22X1_13/a_11_6# Gnd nfet w=20 l=2
+  ad=0.2n pd=60u as=59.999996p ps=46u
M2568 AOI22X1_13/a_11_6# shield_coord_x[2] gnd Gnd nfet w=20 l=2
+  ad=0 pd=0 as=0 ps=0
M2569 AOI22X1_13/a_2_54# INVX2_20/Y vdd vdd pfet w=40 l=2
+  ad=0.64n pd=0.272m as=0 ps=0
M2570 AOI22X1_13/a_28_6# player_bullet_coord_x[1] AOI22X1_13/Y Gnd nfet w=20 l=2
+  ad=0 pd=0 as=0 ps=0
M2571 vdd shield_coord_x[2] AOI22X1_13/a_2_54# vdd pfet w=40 l=2
+  ad=0 pd=0 as=0 ps=0
M2572 AOI22X1_13/Y player_bullet_coord_x[1] AOI22X1_13/a_2_54# vdd pfet w=40 l=2
+  ad=0.24n pd=92u as=0 ps=0
M2573 AOI22X1_13/a_2_54# shield_coord_x[1] AOI22X1_13/Y vdd pfet w=40 l=2
+  ad=0 pd=0 as=0 ps=0
M2574 gnd AOI22X1_48/C AOI22X1_24/a_28_6# Gnd nfet w=20 l=2
+  ad=0 pd=0 as=59.999996p ps=46u
M2575 NOR2X1_27/B NOR2X1_28/Y AOI22X1_24/a_11_6# Gnd nfet w=20 l=2
+  ad=0.2n pd=60u as=59.999996p ps=46u
M2576 AOI22X1_24/a_11_6# INVX2_24/Y gnd Gnd nfet w=20 l=2
+  ad=0 pd=0 as=0 ps=0
M2577 AOI22X1_24/a_2_54# NOR2X1_28/Y vdd vdd pfet w=40 l=2
+  ad=0.64n pd=0.272m as=0 ps=0
M2578 AOI22X1_24/a_28_6# INVX2_17/Y NOR2X1_27/B Gnd nfet w=20 l=2
+  ad=0 pd=0 as=0 ps=0
M2579 vdd INVX2_24/Y AOI22X1_24/a_2_54# vdd pfet w=40 l=2
+  ad=0 pd=0 as=0 ps=0
M2580 NOR2X1_27/B INVX2_17/Y AOI22X1_24/a_2_54# vdd pfet w=40 l=2
+  ad=0.24n pd=92u as=0 ps=0
M2581 AOI22X1_24/a_2_54# AOI22X1_48/C NOR2X1_27/B vdd pfet w=40 l=2
+  ad=0 pd=0 as=0 ps=0
M2582 gnd player_coord_x[2] AOI22X1_46/a_28_6# Gnd nfet w=20 l=2
+  ad=0 pd=0 as=59.999996p ps=46u
M2583 AOI22X1_46/Y AOI22X1_46/B AOI22X1_46/a_11_6# Gnd nfet w=20 l=2
+  ad=0.2n pd=60u as=59.999996p ps=46u
M2584 AOI22X1_46/a_11_6# XNOR2X1_4/Y gnd Gnd nfet w=20 l=2
+  ad=0 pd=0 as=0 ps=0
M2585 AOI22X1_46/a_2_54# AOI22X1_46/B vdd vdd pfet w=40 l=2
+  ad=0.64n pd=0.272m as=0 ps=0
M2586 AOI22X1_46/a_28_6# INVX2_4/Y AOI22X1_46/Y Gnd nfet w=20 l=2
+  ad=0 pd=0 as=0 ps=0
M2587 vdd XNOR2X1_4/Y AOI22X1_46/a_2_54# vdd pfet w=40 l=2
+  ad=0 pd=0 as=0 ps=0
M2588 AOI22X1_46/Y INVX2_4/Y AOI22X1_46/a_2_54# vdd pfet w=40 l=2
+  ad=0.24n pd=92u as=0 ps=0
M2589 AOI22X1_46/a_2_54# player_coord_x[2] AOI22X1_46/Y vdd pfet w=40 l=2
+  ad=0 pd=0 as=0 ps=0
M2590 gnd INVX2_55/Y AOI22X1_35/a_28_6# Gnd nfet w=20 l=2
+  ad=0 pd=0 as=59.999996p ps=46u
M2591 INVX2_156/A AND2X2_8/A AOI22X1_35/a_11_6# Gnd nfet w=20 l=2
+  ad=0.2n pd=60u as=59.999996p ps=46u
M2592 AOI22X1_35/a_11_6# INVX2_55/Y gnd Gnd nfet w=20 l=2
+  ad=0 pd=0 as=0 ps=0
M2593 AOI22X1_35/a_2_54# AND2X2_8/A vdd vdd pfet w=40 l=2
+  ad=0.64n pd=0.272m as=0 ps=0
M2594 AOI22X1_35/a_28_6# AND2X2_9/B INVX2_156/A Gnd nfet w=20 l=2
+  ad=0 pd=0 as=0 ps=0
M2595 vdd INVX2_55/Y AOI22X1_35/a_2_54# vdd pfet w=40 l=2
+  ad=0 pd=0 as=0 ps=0
M2596 INVX2_156/A AND2X2_9/B AOI22X1_35/a_2_54# vdd pfet w=40 l=2
+  ad=0.24n pd=92u as=0 ps=0
M2597 AOI22X1_35/a_2_54# INVX2_55/Y INVX2_156/A vdd pfet w=40 l=2
+  ad=0 pd=0 as=0 ps=0
M2598 gnd XOR2X1_16/Y AOI22X1_57/a_28_6# Gnd nfet w=20 l=2
+  ad=0 pd=0 as=59.999996p ps=46u
M2599 NAND2X1_68/A XOR2X1_17/Y AOI22X1_57/a_11_6# Gnd nfet w=20 l=2
+  ad=0.2n pd=60u as=59.999996p ps=46u
M2600 AOI22X1_57/a_11_6# INVX2_110/Y gnd Gnd nfet w=20 l=2
+  ad=0 pd=0 as=0 ps=0
M2601 AOI22X1_57/a_2_54# XOR2X1_17/Y vdd vdd pfet w=40 l=2
+  ad=0.64n pd=0.272m as=0 ps=0
M2602 AOI22X1_57/a_28_6# INVX2_110/A NAND2X1_68/A Gnd nfet w=20 l=2
+  ad=0 pd=0 as=0 ps=0
M2603 vdd INVX2_110/Y AOI22X1_57/a_2_54# vdd pfet w=40 l=2
+  ad=0 pd=0 as=0 ps=0
M2604 NAND2X1_68/A INVX2_110/A AOI22X1_57/a_2_54# vdd pfet w=40 l=2
+  ad=0.24n pd=92u as=0 ps=0
M2605 AOI22X1_57/a_2_54# XOR2X1_16/Y NAND2X1_68/A vdd pfet w=40 l=2
+  ad=0 pd=0 as=0 ps=0
M2606 gnd OAI22X1_8/A OAI22X1_8/a_2_6# Gnd nfet w=20 l=2
+  ad=0 pd=0 as=0.32n ps=0.152m
M2607 OAI22X1_8/a_2_6# INVX2_55/Y OAI22X1_8/Y Gnd nfet w=20 l=2
+  ad=0 pd=0 as=0.12n ps=52u
M2608 OAI22X1_8/Y OAI22X1_8/D OAI22X1_8/a_2_6# Gnd nfet w=20 l=2
+  ad=0 pd=0 as=0 ps=0
M2609 OAI22X1_8/Y INVX2_25/Y OAI22X1_8/a_9_54# vdd pfet w=40 l=2
+  ad=0.48n pd=0.104m as=0.12n ps=86u
M2610 OAI22X1_8/a_28_54# OAI22X1_8/D OAI22X1_8/Y vdd pfet w=40 l=2
+  ad=0.12n pd=86u as=0 ps=0
M2611 OAI22X1_8/a_9_54# OAI22X1_8/A vdd vdd pfet w=40 l=2
+  ad=0 pd=0 as=0 ps=0
M2612 OAI22X1_8/a_2_6# INVX2_25/Y gnd Gnd nfet w=20 l=2
+  ad=0 pd=0 as=0 ps=0
M2613 vdd INVX2_55/Y OAI22X1_8/a_28_54# vdd pfet w=40 l=2
+  ad=0 pd=0 as=0 ps=0
M2614 INVX2_17/Y INVX2_17/A gnd Gnd nfet w=20 l=2
+  ad=100p pd=50u as=0 ps=0
M2615 INVX2_17/Y INVX2_17/A vdd vdd pfet w=40 l=2
+  ad=0.2n pd=90u as=0 ps=0
M2616 INVX2_39/Y INVX2_39/A gnd Gnd nfet w=20 l=2
+  ad=100p pd=50u as=0 ps=0
M2617 INVX2_39/Y INVX2_39/A vdd vdd pfet w=40 l=2
+  ad=0.2n pd=90u as=0 ps=0
M2618 INVX2_28/Y INVX2_28/A gnd Gnd nfet w=20 l=2
+  ad=100p pd=50u as=0 ps=0
M2619 INVX2_28/Y INVX2_28/A vdd vdd pfet w=40 l=2
+  ad=0.2n pd=90u as=0 ps=0
M2620 gnd XOR2X1_0/A XOR2X1_0/a_2_6# Gnd nfet w=20 l=2
+  ad=0 pd=0 as=100p ps=50u
M2621 XOR2X1_0/Y XOR2X1_0/a_2_6# XOR2X1_0/a_18_6# Gnd nfet w=20 l=2
+  ad=0.2n pd=60u as=59.999996p ps=46u
M2622 XOR2X1_0/a_13_43# player_bullet_coord_x[3] gnd Gnd nfet w=20 l=2
+  ad=100p pd=50u as=0 ps=0
M2623 XOR2X1_0/a_18_54# XOR2X1_0/a_13_43# vdd vdd pfet w=40 l=2
+  ad=0.12n pd=86u as=0 ps=0
M2624 XOR2X1_0/a_35_6# XOR2X1_0/A XOR2X1_0/Y Gnd nfet w=20 l=2
+  ad=59.999996p pd=46u as=0 ps=0
M2625 XOR2X1_0/a_18_6# XOR2X1_0/a_13_43# gnd Gnd nfet w=20 l=2
+  ad=0 pd=0 as=0 ps=0
M2626 vdd XOR2X1_0/A XOR2X1_0/a_2_6# vdd pfet w=40 l=2
+  ad=0 pd=0 as=0.2n ps=90u
M2627 vdd player_bullet_coord_x[3] XOR2X1_0/a_35_54# vdd pfet w=40 l=2
+  ad=0 pd=0 as=0.12n ps=86u
M2628 XOR2X1_0/Y XOR2X1_0/A XOR2X1_0/a_18_54# vdd pfet w=40 l=2
+  ad=0.4n pd=100u as=0 ps=0
M2629 XOR2X1_0/a_35_54# XOR2X1_0/a_2_6# XOR2X1_0/Y vdd pfet w=40 l=2
+  ad=0 pd=0 as=0 ps=0
M2630 XOR2X1_0/a_13_43# player_bullet_coord_x[3] vdd vdd pfet w=40 l=2
+  ad=0.2n pd=90u as=0 ps=0
M2631 gnd player_bullet_coord_x[3] XOR2X1_0/a_35_6# Gnd nfet w=20 l=2
+  ad=0 pd=0 as=0 ps=0
M2632 INVX2_140/Y INVX2_140/A gnd Gnd nfet w=20 l=2
+  ad=100p pd=50u as=0 ps=0
M2633 INVX2_140/Y INVX2_140/A vdd vdd pfet w=40 l=2
+  ad=0.2n pd=90u as=0 ps=0
M2634 INVX2_162/Y INVX2_162/A gnd Gnd nfet w=20 l=2
+  ad=100p pd=50u as=0 ps=0
M2635 INVX2_162/Y INVX2_162/A vdd vdd pfet w=40 l=2
+  ad=0.2n pd=90u as=0 ps=0
M2636 INVX2_151/Y INVX2_151/A gnd Gnd nfet w=20 l=2
+  ad=100p pd=50u as=0 ps=0
M2637 INVX2_151/Y INVX2_151/A vdd vdd pfet w=40 l=2
+  ad=0.2n pd=90u as=0 ps=0
M2638 INVX2_173/Y INVX2_173/A gnd Gnd nfet w=20 l=2
+  ad=100p pd=50u as=0 ps=0
M2639 INVX2_173/Y INVX2_173/A vdd vdd pfet w=40 l=2
+  ad=0.2n pd=90u as=0 ps=0
M2640 OAI22X1_8/A OAI22X1_8/D gnd Gnd nfet w=20 l=2
+  ad=100p pd=50u as=0 ps=0
M2641 OAI22X1_8/A OAI22X1_8/D vdd vdd pfet w=40 l=2
+  ad=0.2n pd=90u as=0 ps=0
M2642 DFFNEGX1_13/a_76_6# clka DFFNEGX1_13/a_66_6# Gnd nfet w=10 l=2
+  ad=29.999998p pd=26u as=80p ps=36u
M2643 gnd clka DFFNEGX1_13/a_2_6# Gnd nfet w=20 l=2
+  ad=0 pd=0 as=100p ps=50u
M2644 DFFNEGX1_13/a_66_6# DFFNEGX1_13/a_2_6# DFFNEGX1_13/a_61_6# Gnd nfet w=10 l=2
+  ad=0 pd=0 as=29.999998p ps=26u
M2645 INVX2_16/A DFFNEGX1_13/a_66_6# gnd Gnd nfet w=20 l=2
+  ad=100p pd=50u as=0 ps=0
M2646 DFFNEGX1_13/a_23_6# clka DFFNEGX1_13/a_17_6# Gnd nfet w=10 l=2
+  ad=59.999996p pd=32u as=40p ps=28u
M2647 DFFNEGX1_13/a_23_6# DFFNEGX1_13/a_2_6# DFFNEGX1_13/a_17_74# vdd pfet w=20 l=2
+  ad=0.12n pd=52u as=80p ps=48u
M2648 gnd DFFNEGX1_13/a_34_4# DFFNEGX1_13/a_31_6# Gnd nfet w=10 l=2
+  ad=0 pd=0 as=29.999998p ps=26u
M2649 vdd DFFNEGX1_13/a_34_4# DFFNEGX1_13/a_31_74# vdd pfet w=20 l=2
+  ad=0 pd=0 as=80p ps=48u
M2650 DFFNEGX1_13/a_61_74# DFFNEGX1_13/a_34_4# vdd vdd pfet w=20 l=2
+  ad=59.999996p pd=46u as=0 ps=0
M2651 DFFNEGX1_13/a_34_4# DFFNEGX1_13/a_23_6# vdd vdd pfet w=20 l=2
+  ad=100p pd=50u as=0 ps=0
M2652 DFFNEGX1_13/a_34_4# DFFNEGX1_13/a_23_6# gnd Gnd nfet w=10 l=2
+  ad=50p pd=30u as=0 ps=0
M2653 vdd INVX2_16/A DFFNEGX1_13/a_76_84# vdd pfet w=10 l=2
+  ad=0 pd=0 as=29.999998p ps=26u
M2654 gnd INVX2_16/A DFFNEGX1_13/a_76_6# Gnd nfet w=10 l=2
+  ad=0 pd=0 as=0 ps=0
M2655 DFFNEGX1_13/a_61_6# DFFNEGX1_13/a_34_4# gnd Gnd nfet w=10 l=2
+  ad=0 pd=0 as=0 ps=0
M2656 DFFNEGX1_13/a_76_84# DFFNEGX1_13/a_2_6# DFFNEGX1_13/a_66_6# vdd pfet w=10 l=2
+  ad=0 pd=0 as=0.15n ps=56u
M2657 INVX2_16/A DFFNEGX1_13/a_66_6# vdd vdd pfet w=40 l=2
+  ad=0.2n pd=90u as=0 ps=0
M2658 vdd clka DFFNEGX1_13/a_2_6# vdd pfet w=40 l=2
+  ad=0 pd=0 as=0.2n ps=90u
M2659 DFFNEGX1_13/a_31_6# DFFNEGX1_13/a_2_6# DFFNEGX1_13/a_23_6# Gnd nfet w=10 l=2
+  ad=0 pd=0 as=0 ps=0
M2660 DFFNEGX1_13/a_66_6# clka DFFNEGX1_13/a_61_74# vdd pfet w=20 l=2
+  ad=0 pd=0 as=0 ps=0
M2661 DFFNEGX1_13/a_17_74# NOR2X1_27/Y vdd vdd pfet w=20 l=2
+  ad=0 pd=0 as=0 ps=0
M2662 DFFNEGX1_13/a_31_74# clka DFFNEGX1_13/a_23_6# vdd pfet w=20 l=2
+  ad=0 pd=0 as=0 ps=0
M2663 DFFNEGX1_13/a_17_6# NOR2X1_27/Y gnd Gnd nfet w=10 l=2
+  ad=0 pd=0 as=0 ps=0
M2664 DFFNEGX1_24/a_76_6# BUFX2_6/Y DFFNEGX1_24/a_66_6# Gnd nfet w=10 l=2
+  ad=29.999998p pd=26u as=80p ps=36u
M2665 gnd BUFX2_6/Y DFFNEGX1_24/a_2_6# Gnd nfet w=20 l=2
+  ad=0 pd=0 as=100p ps=50u
M2666 DFFNEGX1_24/a_66_6# DFFNEGX1_24/a_2_6# DFFNEGX1_24/a_61_6# Gnd nfet w=10 l=2
+  ad=0 pd=0 as=29.999998p ps=26u
M2667 INVX2_27/A DFFNEGX1_24/a_66_6# gnd Gnd nfet w=20 l=2
+  ad=100p pd=50u as=0 ps=0
M2668 DFFNEGX1_24/a_23_6# BUFX2_6/Y DFFNEGX1_24/a_17_6# Gnd nfet w=10 l=2
+  ad=59.999996p pd=32u as=40p ps=28u
M2669 DFFNEGX1_24/a_23_6# DFFNEGX1_24/a_2_6# DFFNEGX1_24/a_17_74# vdd pfet w=20 l=2
+  ad=0.12n pd=52u as=80p ps=48u
M2670 gnd DFFNEGX1_24/a_34_4# DFFNEGX1_24/a_31_6# Gnd nfet w=10 l=2
+  ad=0 pd=0 as=29.999998p ps=26u
M2671 vdd DFFNEGX1_24/a_34_4# DFFNEGX1_24/a_31_74# vdd pfet w=20 l=2
+  ad=0 pd=0 as=80p ps=48u
M2672 DFFNEGX1_24/a_61_74# DFFNEGX1_24/a_34_4# vdd vdd pfet w=20 l=2
+  ad=59.999996p pd=46u as=0 ps=0
M2673 DFFNEGX1_24/a_34_4# DFFNEGX1_24/a_23_6# vdd vdd pfet w=20 l=2
+  ad=100p pd=50u as=0 ps=0
M2674 DFFNEGX1_24/a_34_4# DFFNEGX1_24/a_23_6# gnd Gnd nfet w=10 l=2
+  ad=50p pd=30u as=0 ps=0
M2675 vdd INVX2_27/A DFFNEGX1_24/a_76_84# vdd pfet w=10 l=2
+  ad=0 pd=0 as=29.999998p ps=26u
M2676 gnd INVX2_27/A DFFNEGX1_24/a_76_6# Gnd nfet w=10 l=2
+  ad=0 pd=0 as=0 ps=0
M2677 DFFNEGX1_24/a_61_6# DFFNEGX1_24/a_34_4# gnd Gnd nfet w=10 l=2
+  ad=0 pd=0 as=0 ps=0
M2678 DFFNEGX1_24/a_76_84# DFFNEGX1_24/a_2_6# DFFNEGX1_24/a_66_6# vdd pfet w=10 l=2
+  ad=0 pd=0 as=0.15n ps=56u
M2679 INVX2_27/A DFFNEGX1_24/a_66_6# vdd vdd pfet w=40 l=2
+  ad=0.2n pd=90u as=0 ps=0
M2680 vdd BUFX2_6/Y DFFNEGX1_24/a_2_6# vdd pfet w=40 l=2
+  ad=0 pd=0 as=0.2n ps=90u
M2681 DFFNEGX1_24/a_31_6# DFFNEGX1_24/a_2_6# DFFNEGX1_24/a_23_6# Gnd nfet w=10 l=2
+  ad=0 pd=0 as=0 ps=0
M2682 DFFNEGX1_24/a_66_6# BUFX2_6/Y DFFNEGX1_24/a_61_74# vdd pfet w=20 l=2
+  ad=0 pd=0 as=0 ps=0
M2683 DFFNEGX1_24/a_17_74# OAI21X1_56/Y vdd vdd pfet w=20 l=2
+  ad=0 pd=0 as=0 ps=0
M2684 DFFNEGX1_24/a_31_74# BUFX2_6/Y DFFNEGX1_24/a_23_6# vdd pfet w=20 l=2
+  ad=0 pd=0 as=0 ps=0
M2685 DFFNEGX1_24/a_17_6# OAI21X1_56/Y gnd Gnd nfet w=10 l=2
+  ad=0 pd=0 as=0 ps=0
M2686 DFFNEGX1_46/a_76_6# BUFX2_4/Y DFFNEGX1_46/a_66_6# Gnd nfet w=10 l=2
+  ad=29.999998p pd=26u as=80p ps=36u
M2687 gnd BUFX2_4/Y DFFNEGX1_46/a_2_6# Gnd nfet w=20 l=2
+  ad=0 pd=0 as=100p ps=50u
M2688 DFFNEGX1_46/a_66_6# DFFNEGX1_46/a_2_6# DFFNEGX1_46/a_61_6# Gnd nfet w=10 l=2
+  ad=0 pd=0 as=29.999998p ps=26u
M2689 invader_1_coord_x[1] DFFNEGX1_46/a_66_6# gnd Gnd nfet w=20 l=2
+  ad=100p pd=50u as=0 ps=0
M2690 DFFNEGX1_46/a_23_6# BUFX2_4/Y DFFNEGX1_46/a_17_6# Gnd nfet w=10 l=2
+  ad=59.999996p pd=32u as=40p ps=28u
M2691 DFFNEGX1_46/a_23_6# DFFNEGX1_46/a_2_6# DFFNEGX1_46/a_17_74# vdd pfet w=20 l=2
+  ad=0.12n pd=52u as=80p ps=48u
M2692 gnd DFFNEGX1_46/a_34_4# DFFNEGX1_46/a_31_6# Gnd nfet w=10 l=2
+  ad=0 pd=0 as=29.999998p ps=26u
M2693 vdd DFFNEGX1_46/a_34_4# DFFNEGX1_46/a_31_74# vdd pfet w=20 l=2
+  ad=0 pd=0 as=80p ps=48u
M2694 DFFNEGX1_46/a_61_74# DFFNEGX1_46/a_34_4# vdd vdd pfet w=20 l=2
+  ad=59.999996p pd=46u as=0 ps=0
M2695 DFFNEGX1_46/a_34_4# DFFNEGX1_46/a_23_6# vdd vdd pfet w=20 l=2
+  ad=100p pd=50u as=0 ps=0
M2696 DFFNEGX1_46/a_34_4# DFFNEGX1_46/a_23_6# gnd Gnd nfet w=10 l=2
+  ad=50p pd=30u as=0 ps=0
M2697 vdd invader_1_coord_x[1] DFFNEGX1_46/a_76_84# vdd pfet w=10 l=2
+  ad=0 pd=0 as=29.999998p ps=26u
M2698 gnd invader_1_coord_x[1] DFFNEGX1_46/a_76_6# Gnd nfet w=10 l=2
+  ad=0 pd=0 as=0 ps=0
M2699 DFFNEGX1_46/a_61_6# DFFNEGX1_46/a_34_4# gnd Gnd nfet w=10 l=2
+  ad=0 pd=0 as=0 ps=0
M2700 DFFNEGX1_46/a_76_84# DFFNEGX1_46/a_2_6# DFFNEGX1_46/a_66_6# vdd pfet w=10 l=2
+  ad=0 pd=0 as=0.15n ps=56u
M2701 invader_1_coord_x[1] DFFNEGX1_46/a_66_6# vdd vdd pfet w=40 l=2
+  ad=0.2n pd=90u as=0 ps=0
M2702 vdd BUFX2_4/Y DFFNEGX1_46/a_2_6# vdd pfet w=40 l=2
+  ad=0 pd=0 as=0.2n ps=90u
M2703 DFFNEGX1_46/a_31_6# DFFNEGX1_46/a_2_6# DFFNEGX1_46/a_23_6# Gnd nfet w=10 l=2
+  ad=0 pd=0 as=0 ps=0
M2704 DFFNEGX1_46/a_66_6# BUFX2_4/Y DFFNEGX1_46/a_61_74# vdd pfet w=20 l=2
+  ad=0 pd=0 as=0 ps=0
M2705 DFFNEGX1_46/a_17_74# OAI21X1_80/Y vdd vdd pfet w=20 l=2
+  ad=0 pd=0 as=0 ps=0
M2706 DFFNEGX1_46/a_31_74# BUFX2_4/Y DFFNEGX1_46/a_23_6# vdd pfet w=20 l=2
+  ad=0 pd=0 as=0 ps=0
M2707 DFFNEGX1_46/a_17_6# OAI21X1_80/Y gnd Gnd nfet w=10 l=2
+  ad=0 pd=0 as=0 ps=0
M2708 DFFNEGX1_68/a_76_6# clka DFFNEGX1_68/a_66_6# Gnd nfet w=10 l=2
+  ad=29.999998p pd=26u as=80p ps=36u
M2709 gnd clka DFFNEGX1_68/a_2_6# Gnd nfet w=20 l=2
+  ad=0 pd=0 as=100p ps=50u
M2710 DFFNEGX1_68/a_66_6# DFFNEGX1_68/a_2_6# DFFNEGX1_68/a_61_6# Gnd nfet w=10 l=2
+  ad=0 pd=0 as=29.999998p ps=26u
M2711 INVX2_98/A DFFNEGX1_68/a_66_6# gnd Gnd nfet w=20 l=2
+  ad=100p pd=50u as=0 ps=0
M2712 DFFNEGX1_68/a_23_6# clka DFFNEGX1_68/a_17_6# Gnd nfet w=10 l=2
+  ad=59.999996p pd=32u as=40p ps=28u
M2713 DFFNEGX1_68/a_23_6# DFFNEGX1_68/a_2_6# DFFNEGX1_68/a_17_74# vdd pfet w=20 l=2
+  ad=0.12n pd=52u as=80p ps=48u
M2714 gnd DFFNEGX1_68/a_34_4# DFFNEGX1_68/a_31_6# Gnd nfet w=10 l=2
+  ad=0 pd=0 as=29.999998p ps=26u
M2715 vdd DFFNEGX1_68/a_34_4# DFFNEGX1_68/a_31_74# vdd pfet w=20 l=2
+  ad=0 pd=0 as=80p ps=48u
M2716 DFFNEGX1_68/a_61_74# DFFNEGX1_68/a_34_4# vdd vdd pfet w=20 l=2
+  ad=59.999996p pd=46u as=0 ps=0
M2717 DFFNEGX1_68/a_34_4# DFFNEGX1_68/a_23_6# vdd vdd pfet w=20 l=2
+  ad=100p pd=50u as=0 ps=0
M2718 DFFNEGX1_68/a_34_4# DFFNEGX1_68/a_23_6# gnd Gnd nfet w=10 l=2
+  ad=50p pd=30u as=0 ps=0
M2719 vdd INVX2_98/A DFFNEGX1_68/a_76_84# vdd pfet w=10 l=2
+  ad=0 pd=0 as=29.999998p ps=26u
M2720 gnd INVX2_98/A DFFNEGX1_68/a_76_6# Gnd nfet w=10 l=2
+  ad=0 pd=0 as=0 ps=0
M2721 DFFNEGX1_68/a_61_6# DFFNEGX1_68/a_34_4# gnd Gnd nfet w=10 l=2
+  ad=0 pd=0 as=0 ps=0
M2722 DFFNEGX1_68/a_76_84# DFFNEGX1_68/a_2_6# DFFNEGX1_68/a_66_6# vdd pfet w=10 l=2
+  ad=0 pd=0 as=0.15n ps=56u
M2723 INVX2_98/A DFFNEGX1_68/a_66_6# vdd vdd pfet w=40 l=2
+  ad=0.2n pd=90u as=0 ps=0
M2724 vdd clka DFFNEGX1_68/a_2_6# vdd pfet w=40 l=2
+  ad=0 pd=0 as=0.2n ps=90u
M2725 DFFNEGX1_68/a_31_6# DFFNEGX1_68/a_2_6# DFFNEGX1_68/a_23_6# Gnd nfet w=10 l=2
+  ad=0 pd=0 as=0 ps=0
M2726 DFFNEGX1_68/a_66_6# clka DFFNEGX1_68/a_61_74# vdd pfet w=20 l=2
+  ad=0 pd=0 as=0 ps=0
M2727 DFFNEGX1_68/a_17_74# NOR2X1_49/Y vdd vdd pfet w=20 l=2
+  ad=0 pd=0 as=0 ps=0
M2728 DFFNEGX1_68/a_31_74# clka DFFNEGX1_68/a_23_6# vdd pfet w=20 l=2
+  ad=0 pd=0 as=0 ps=0
M2729 DFFNEGX1_68/a_17_6# NOR2X1_49/Y gnd Gnd nfet w=10 l=2
+  ad=0 pd=0 as=0 ps=0
M2730 DFFNEGX1_57/a_76_6# BUFX2_4/Y DFFNEGX1_57/a_66_6# Gnd nfet w=10 l=2
+  ad=29.999998p pd=26u as=80p ps=36u
M2731 gnd BUFX2_4/Y DFFNEGX1_57/a_2_6# Gnd nfet w=20 l=2
+  ad=0 pd=0 as=100p ps=50u
M2732 DFFNEGX1_57/a_66_6# DFFNEGX1_57/a_2_6# DFFNEGX1_57/a_61_6# Gnd nfet w=10 l=2
+  ad=0 pd=0 as=29.999998p ps=26u
M2733 INVX2_87/A DFFNEGX1_57/a_66_6# gnd Gnd nfet w=20 l=2
+  ad=100p pd=50u as=0 ps=0
M2734 DFFNEGX1_57/a_23_6# BUFX2_4/Y DFFNEGX1_57/a_17_6# Gnd nfet w=10 l=2
+  ad=59.999996p pd=32u as=40p ps=28u
M2735 DFFNEGX1_57/a_23_6# DFFNEGX1_57/a_2_6# DFFNEGX1_57/a_17_74# vdd pfet w=20 l=2
+  ad=0.12n pd=52u as=80p ps=48u
M2736 gnd DFFNEGX1_57/a_34_4# DFFNEGX1_57/a_31_6# Gnd nfet w=10 l=2
+  ad=0 pd=0 as=29.999998p ps=26u
M2737 vdd DFFNEGX1_57/a_34_4# DFFNEGX1_57/a_31_74# vdd pfet w=20 l=2
+  ad=0 pd=0 as=80p ps=48u
M2738 DFFNEGX1_57/a_61_74# DFFNEGX1_57/a_34_4# vdd vdd pfet w=20 l=2
+  ad=59.999996p pd=46u as=0 ps=0
M2739 DFFNEGX1_57/a_34_4# DFFNEGX1_57/a_23_6# vdd vdd pfet w=20 l=2
+  ad=100p pd=50u as=0 ps=0
M2740 DFFNEGX1_57/a_34_4# DFFNEGX1_57/a_23_6# gnd Gnd nfet w=10 l=2
+  ad=50p pd=30u as=0 ps=0
M2741 vdd INVX2_87/A DFFNEGX1_57/a_76_84# vdd pfet w=10 l=2
+  ad=0 pd=0 as=29.999998p ps=26u
M2742 gnd INVX2_87/A DFFNEGX1_57/a_76_6# Gnd nfet w=10 l=2
+  ad=0 pd=0 as=0 ps=0
M2743 DFFNEGX1_57/a_61_6# DFFNEGX1_57/a_34_4# gnd Gnd nfet w=10 l=2
+  ad=0 pd=0 as=0 ps=0
M2744 DFFNEGX1_57/a_76_84# DFFNEGX1_57/a_2_6# DFFNEGX1_57/a_66_6# vdd pfet w=10 l=2
+  ad=0 pd=0 as=0.15n ps=56u
M2745 INVX2_87/A DFFNEGX1_57/a_66_6# vdd vdd pfet w=40 l=2
+  ad=0.2n pd=90u as=0 ps=0
M2746 vdd BUFX2_4/Y DFFNEGX1_57/a_2_6# vdd pfet w=40 l=2
+  ad=0 pd=0 as=0.2n ps=90u
M2747 DFFNEGX1_57/a_31_6# DFFNEGX1_57/a_2_6# DFFNEGX1_57/a_23_6# Gnd nfet w=10 l=2
+  ad=0 pd=0 as=0 ps=0
M2748 DFFNEGX1_57/a_66_6# BUFX2_4/Y DFFNEGX1_57/a_61_74# vdd pfet w=20 l=2
+  ad=0 pd=0 as=0 ps=0
M2749 DFFNEGX1_57/a_17_74# NOR2X1_39/Y vdd vdd pfet w=20 l=2
+  ad=0 pd=0 as=0 ps=0
M2750 DFFNEGX1_57/a_31_74# BUFX2_4/Y DFFNEGX1_57/a_23_6# vdd pfet w=20 l=2
+  ad=0 pd=0 as=0 ps=0
M2751 DFFNEGX1_57/a_17_6# NOR2X1_39/Y gnd Gnd nfet w=10 l=2
+  ad=0 pd=0 as=0 ps=0
M2752 DFFNEGX1_35/a_76_6# BUFX2_5/Y DFFNEGX1_35/a_66_6# Gnd nfet w=10 l=2
+  ad=29.999998p pd=26u as=80p ps=36u
M2753 gnd BUFX2_5/Y DFFNEGX1_35/a_2_6# Gnd nfet w=20 l=2
+  ad=0 pd=0 as=100p ps=50u
M2754 DFFNEGX1_35/a_66_6# DFFNEGX1_35/a_2_6# DFFNEGX1_35/a_61_6# Gnd nfet w=10 l=2
+  ad=0 pd=0 as=29.999998p ps=26u
M2755 invader_2_coord_x[1] DFFNEGX1_35/a_66_6# gnd Gnd nfet w=20 l=2
+  ad=100p pd=50u as=0 ps=0
M2756 DFFNEGX1_35/a_23_6# BUFX2_5/Y DFFNEGX1_35/a_17_6# Gnd nfet w=10 l=2
+  ad=59.999996p pd=32u as=40p ps=28u
M2757 DFFNEGX1_35/a_23_6# DFFNEGX1_35/a_2_6# DFFNEGX1_35/a_17_74# vdd pfet w=20 l=2
+  ad=0.12n pd=52u as=80p ps=48u
M2758 gnd DFFNEGX1_35/a_34_4# DFFNEGX1_35/a_31_6# Gnd nfet w=10 l=2
+  ad=0 pd=0 as=29.999998p ps=26u
M2759 vdd DFFNEGX1_35/a_34_4# DFFNEGX1_35/a_31_74# vdd pfet w=20 l=2
+  ad=0 pd=0 as=80p ps=48u
M2760 DFFNEGX1_35/a_61_74# DFFNEGX1_35/a_34_4# vdd vdd pfet w=20 l=2
+  ad=59.999996p pd=46u as=0 ps=0
M2761 DFFNEGX1_35/a_34_4# DFFNEGX1_35/a_23_6# vdd vdd pfet w=20 l=2
+  ad=100p pd=50u as=0 ps=0
M2762 DFFNEGX1_35/a_34_4# DFFNEGX1_35/a_23_6# gnd Gnd nfet w=10 l=2
+  ad=50p pd=30u as=0 ps=0
M2763 vdd invader_2_coord_x[1] DFFNEGX1_35/a_76_84# vdd pfet w=10 l=2
+  ad=0 pd=0 as=29.999998p ps=26u
M2764 gnd invader_2_coord_x[1] DFFNEGX1_35/a_76_6# Gnd nfet w=10 l=2
+  ad=0 pd=0 as=0 ps=0
M2765 DFFNEGX1_35/a_61_6# DFFNEGX1_35/a_34_4# gnd Gnd nfet w=10 l=2
+  ad=0 pd=0 as=0 ps=0
M2766 DFFNEGX1_35/a_76_84# DFFNEGX1_35/a_2_6# DFFNEGX1_35/a_66_6# vdd pfet w=10 l=2
+  ad=0 pd=0 as=0.15n ps=56u
M2767 invader_2_coord_x[1] DFFNEGX1_35/a_66_6# vdd vdd pfet w=40 l=2
+  ad=0.2n pd=90u as=0 ps=0
M2768 vdd BUFX2_5/Y DFFNEGX1_35/a_2_6# vdd pfet w=40 l=2
+  ad=0 pd=0 as=0.2n ps=90u
M2769 DFFNEGX1_35/a_31_6# DFFNEGX1_35/a_2_6# DFFNEGX1_35/a_23_6# Gnd nfet w=10 l=2
+  ad=0 pd=0 as=0 ps=0
M2770 DFFNEGX1_35/a_66_6# BUFX2_5/Y DFFNEGX1_35/a_61_74# vdd pfet w=20 l=2
+  ad=0 pd=0 as=0 ps=0
M2771 DFFNEGX1_35/a_17_74# OAI21X1_60/Y vdd vdd pfet w=20 l=2
+  ad=0 pd=0 as=0 ps=0
M2772 DFFNEGX1_35/a_31_74# BUFX2_5/Y DFFNEGX1_35/a_23_6# vdd pfet w=20 l=2
+  ad=0 pd=0 as=0 ps=0
M2773 DFFNEGX1_35/a_17_6# OAI21X1_60/Y gnd Gnd nfet w=10 l=2
+  ad=0 pd=0 as=0 ps=0
M2774 DFFNEGX1_79/a_76_6# clka DFFNEGX1_79/a_66_6# Gnd nfet w=10 l=2
+  ad=29.999998p pd=26u as=80p ps=36u
M2775 gnd clka DFFNEGX1_79/a_2_6# Gnd nfet w=20 l=2
+  ad=0 pd=0 as=100p ps=50u
M2776 DFFNEGX1_79/a_66_6# DFFNEGX1_79/a_2_6# DFFNEGX1_79/a_61_6# Gnd nfet w=10 l=2
+  ad=0 pd=0 as=29.999998p ps=26u
M2777 INVX2_128/A DFFNEGX1_79/a_66_6# gnd Gnd nfet w=20 l=2
+  ad=100p pd=50u as=0 ps=0
M2778 DFFNEGX1_79/a_23_6# clka DFFNEGX1_79/a_17_6# Gnd nfet w=10 l=2
+  ad=59.999996p pd=32u as=40p ps=28u
M2779 DFFNEGX1_79/a_23_6# DFFNEGX1_79/a_2_6# DFFNEGX1_79/a_17_74# vdd pfet w=20 l=2
+  ad=0.12n pd=52u as=80p ps=48u
M2780 gnd DFFNEGX1_79/a_34_4# DFFNEGX1_79/a_31_6# Gnd nfet w=10 l=2
+  ad=0 pd=0 as=29.999998p ps=26u
M2781 vdd DFFNEGX1_79/a_34_4# DFFNEGX1_79/a_31_74# vdd pfet w=20 l=2
+  ad=0 pd=0 as=80p ps=48u
M2782 DFFNEGX1_79/a_61_74# DFFNEGX1_79/a_34_4# vdd vdd pfet w=20 l=2
+  ad=59.999996p pd=46u as=0 ps=0
M2783 DFFNEGX1_79/a_34_4# DFFNEGX1_79/a_23_6# vdd vdd pfet w=20 l=2
+  ad=100p pd=50u as=0 ps=0
M2784 DFFNEGX1_79/a_34_4# DFFNEGX1_79/a_23_6# gnd Gnd nfet w=10 l=2
+  ad=50p pd=30u as=0 ps=0
M2785 vdd INVX2_128/A DFFNEGX1_79/a_76_84# vdd pfet w=10 l=2
+  ad=0 pd=0 as=29.999998p ps=26u
M2786 gnd INVX2_128/A DFFNEGX1_79/a_76_6# Gnd nfet w=10 l=2
+  ad=0 pd=0 as=0 ps=0
M2787 DFFNEGX1_79/a_61_6# DFFNEGX1_79/a_34_4# gnd Gnd nfet w=10 l=2
+  ad=0 pd=0 as=0 ps=0
M2788 DFFNEGX1_79/a_76_84# DFFNEGX1_79/a_2_6# DFFNEGX1_79/a_66_6# vdd pfet w=10 l=2
+  ad=0 pd=0 as=0.15n ps=56u
M2789 INVX2_128/A DFFNEGX1_79/a_66_6# vdd vdd pfet w=40 l=2
+  ad=0.2n pd=90u as=0 ps=0
M2790 vdd clka DFFNEGX1_79/a_2_6# vdd pfet w=40 l=2
+  ad=0 pd=0 as=0.2n ps=90u
M2791 DFFNEGX1_79/a_31_6# DFFNEGX1_79/a_2_6# DFFNEGX1_79/a_23_6# Gnd nfet w=10 l=2
+  ad=0 pd=0 as=0 ps=0
M2792 DFFNEGX1_79/a_66_6# clka DFFNEGX1_79/a_61_74# vdd pfet w=20 l=2
+  ad=0 pd=0 as=0 ps=0
M2793 DFFNEGX1_79/a_17_74# NOR2X1_55/Y vdd vdd pfet w=20 l=2
+  ad=0 pd=0 as=0 ps=0
M2794 DFFNEGX1_79/a_31_74# clka DFFNEGX1_79/a_23_6# vdd pfet w=20 l=2
+  ad=0 pd=0 as=0 ps=0
M2795 DFFNEGX1_79/a_17_6# NOR2X1_55/Y gnd Gnd nfet w=10 l=2
+  ad=0 pd=0 as=0 ps=0
M2796 gnd INVX2_90/Y XOR2X1_11/a_2_6# Gnd nfet w=20 l=2
+  ad=0 pd=0 as=100p ps=50u
M2797 XOR2X1_11/Y XOR2X1_11/a_2_6# XOR2X1_11/a_18_6# Gnd nfet w=20 l=2
+  ad=0.2n pd=60u as=59.999996p ps=46u
M2798 XOR2X1_11/a_13_43# invader_bullet_coord_y[2] gnd Gnd nfet w=20 l=2
+  ad=100p pd=50u as=0 ps=0
M2799 XOR2X1_11/a_18_54# XOR2X1_11/a_13_43# vdd vdd pfet w=40 l=2
+  ad=0.12n pd=86u as=0 ps=0
M2800 XOR2X1_11/a_35_6# INVX2_90/Y XOR2X1_11/Y Gnd nfet w=20 l=2
+  ad=59.999996p pd=46u as=0 ps=0
M2801 XOR2X1_11/a_18_6# XOR2X1_11/a_13_43# gnd Gnd nfet w=20 l=2
+  ad=0 pd=0 as=0 ps=0
M2802 vdd INVX2_90/Y XOR2X1_11/a_2_6# vdd pfet w=40 l=2
+  ad=0 pd=0 as=0.2n ps=90u
M2803 vdd invader_bullet_coord_y[2] XOR2X1_11/a_35_54# vdd pfet w=40 l=2
+  ad=0 pd=0 as=0.12n ps=86u
M2804 XOR2X1_11/Y INVX2_90/Y XOR2X1_11/a_18_54# vdd pfet w=40 l=2
+  ad=0.4n pd=100u as=0 ps=0
M2805 XOR2X1_11/a_35_54# XOR2X1_11/a_2_6# XOR2X1_11/Y vdd pfet w=40 l=2
+  ad=0 pd=0 as=0 ps=0
M2806 XOR2X1_11/a_13_43# invader_bullet_coord_y[2] vdd vdd pfet w=40 l=2
+  ad=0.2n pd=90u as=0 ps=0
M2807 gnd invader_bullet_coord_y[2] XOR2X1_11/a_35_6# Gnd nfet w=20 l=2
+  ad=0 pd=0 as=0 ps=0
M2808 OAI21X1_6/C OAI21X1_5/C vdd vdd pfet w=20 l=2
+  ad=0.22n pd=0.102m as=0 ps=0
M2809 NAND3X1_1/a_9_6# OAI21X1_5/C gnd Gnd nfet w=30 l=2
+  ad=90p pd=66u as=0 ps=0
M2810 OAI21X1_6/C player_bullet_coord_x[2] vdd vdd pfet w=20 l=2
+  ad=0 pd=0 as=0 ps=0
M2811 OAI21X1_6/C player_bullet_coord_x[2] NAND3X1_1/a_14_6# Gnd nfet w=30 l=2
+  ad=0.15n pd=70u as=90p ps=66u
M2812 vdd INVX2_46/Y OAI21X1_6/C vdd pfet w=20 l=2
+  ad=0 pd=0 as=0 ps=0
M2813 NAND3X1_1/a_14_6# INVX2_46/Y NAND3X1_1/a_9_6# Gnd nfet w=30 l=2
+  ad=0 pd=0 as=0 ps=0
M2814 gnd INVX2_83/A OAI21X1_130/a_2_6# Gnd nfet w=20 l=2
+  ad=0 pd=0 as=0.22n ps=0.102m
M2815 vdd INVX2_151/Y OAI21X1_130/Y vdd pfet w=20 l=2
+  ad=0 pd=0 as=0.22n ps=92u
M2816 OAI21X1_130/Y INVX2_151/Y OAI21X1_130/a_2_6# Gnd nfet w=20 l=2
+  ad=100p pd=50u as=0 ps=0
M2817 OAI21X1_130/Y INVX2_126/A OAI21X1_130/a_9_54# vdd pfet w=40 l=2
+  ad=0 pd=0 as=0.12n ps=86u
M2818 OAI21X1_130/a_9_54# INVX2_83/A vdd vdd pfet w=40 l=2
+  ad=0 pd=0 as=0 ps=0
M2819 OAI21X1_130/a_2_6# INVX2_126/A gnd Gnd nfet w=20 l=2
+  ad=0 pd=0 as=0 ps=0
M2820 gnd INVX2_78/Y AOI22X1_6/a_28_6# Gnd nfet w=20 l=2
+  ad=0 pd=0 as=59.999996p ps=46u
M2821 OR2X1_3/A INVX2_78/Y AOI22X1_6/a_11_6# Gnd nfet w=20 l=2
+  ad=0.2n pd=60u as=59.999996p ps=46u
M2822 AOI22X1_6/a_11_6# AOI22X1_6/A gnd Gnd nfet w=20 l=2
+  ad=0 pd=0 as=0 ps=0
M2823 AOI22X1_6/a_2_54# INVX2_78/Y vdd vdd pfet w=40 l=2
+  ad=0.64n pd=0.272m as=0 ps=0
M2824 AOI22X1_6/a_28_6# AOI22X1_6/D OR2X1_3/A Gnd nfet w=20 l=2
+  ad=0 pd=0 as=0 ps=0
M2825 vdd AOI22X1_6/A AOI22X1_6/a_2_54# vdd pfet w=40 l=2
+  ad=0 pd=0 as=0 ps=0
M2826 OR2X1_3/A AOI22X1_6/D AOI22X1_6/a_2_54# vdd pfet w=40 l=2
+  ad=0.24n pd=92u as=0 ps=0
M2827 AOI22X1_6/a_2_54# INVX2_78/Y OR2X1_3/A vdd pfet w=40 l=2
+  ad=0 pd=0 as=0 ps=0
M2828 gnd invader_2_coord_x[3] OAI21X1_141/a_2_6# Gnd nfet w=20 l=2
+  ad=0 pd=0 as=0.22n ps=0.102m
M2829 vdd NAND2X1_73/Y INVX2_106/A vdd pfet w=20 l=2
+  ad=0 pd=0 as=0.22n ps=92u
M2830 INVX2_106/A NAND2X1_73/Y OAI21X1_141/a_2_6# Gnd nfet w=20 l=2
+  ad=100p pd=50u as=0 ps=0
M2831 INVX2_106/A INVX2_182/Y OAI21X1_141/a_9_54# vdd pfet w=40 l=2
+  ad=0 pd=0 as=0.12n ps=86u
M2832 OAI21X1_141/a_9_54# invader_2_coord_x[3] vdd vdd pfet w=40 l=2
+  ad=0 pd=0 as=0 ps=0
M2833 OAI21X1_141/a_2_6# INVX2_182/Y gnd Gnd nfet w=20 l=2
+  ad=0 pd=0 as=0 ps=0
M2834 gnd XOR2X1_17/A OAI21X1_152/a_2_6# Gnd nfet w=20 l=2
+  ad=0 pd=0 as=0.22n ps=0.102m
M2835 vdd OAI21X1_153/Y XNOR2X1_8/A vdd pfet w=20 l=2
+  ad=0 pd=0 as=0.22n ps=92u
M2836 XNOR2X1_8/A OAI21X1_153/Y OAI21X1_152/a_2_6# Gnd nfet w=20 l=2
+  ad=100p pd=50u as=0 ps=0
M2837 XNOR2X1_8/A OAI22X1_7/C OAI21X1_152/a_9_54# vdd pfet w=40 l=2
+  ad=0 pd=0 as=0.12n ps=86u
M2838 OAI21X1_152/a_9_54# XOR2X1_17/A vdd vdd pfet w=40 l=2
+  ad=0 pd=0 as=0 ps=0
M2839 OAI21X1_152/a_2_6# OAI22X1_7/C gnd Gnd nfet w=20 l=2
+  ad=0 pd=0 as=0 ps=0
M2840 NAND3X1_3/A INVX2_41/Y vdd vdd pfet w=20 l=2
+  ad=0.12n pd=52u as=0 ps=0
M2841 NAND2X1_16/a_9_6# INVX2_41/Y gnd Gnd nfet w=20 l=2
+  ad=59.999996p pd=46u as=0 ps=0
M2842 vdd INVX2_23/Y NAND3X1_3/A vdd pfet w=20 l=2
+  ad=0 pd=0 as=0 ps=0
M2843 NAND3X1_3/A INVX2_23/Y NAND2X1_16/a_9_6# Gnd nfet w=20 l=2
+  ad=100p pd=50u as=0 ps=0
M2844 NOR2X1_41/B NOR2X1_43/Y vdd vdd pfet w=20 l=2
+  ad=0.12n pd=52u as=0 ps=0
M2845 NAND2X1_49/a_9_6# NOR2X1_43/Y gnd Gnd nfet w=20 l=2
+  ad=59.999996p pd=46u as=0 ps=0
M2846 vdd INVX2_85/Y NOR2X1_41/B vdd pfet w=20 l=2
+  ad=0 pd=0 as=0 ps=0
M2847 NOR2X1_41/B INVX2_85/Y NAND2X1_49/a_9_6# Gnd nfet w=20 l=2
+  ad=100p pd=50u as=0 ps=0
M2848 OAI21X1_34/C invader_bullet_coord_x[3] vdd vdd pfet w=20 l=2
+  ad=0.12n pd=52u as=0 ps=0
M2849 NAND2X1_27/a_9_6# invader_bullet_coord_x[3] gnd Gnd nfet w=20 l=2
+  ad=59.999996p pd=46u as=0 ps=0
M2850 vdd INVX2_121/Y OAI21X1_34/C vdd pfet w=20 l=2
+  ad=0 pd=0 as=0 ps=0
M2851 OAI21X1_34/C INVX2_121/Y NAND2X1_27/a_9_6# Gnd nfet w=20 l=2
+  ad=100p pd=50u as=0 ps=0
M2852 INVX2_30/A NOR2X1_32/B vdd vdd pfet w=20 l=2
+  ad=0.12n pd=52u as=0 ps=0
M2853 NAND2X1_38/a_9_6# NOR2X1_32/B gnd Gnd nfet w=20 l=2
+  ad=59.999996p pd=46u as=0 ps=0
M2854 vdd INVX2_26/Y INVX2_30/A vdd pfet w=20 l=2
+  ad=0 pd=0 as=0 ps=0
M2855 INVX2_30/A INVX2_26/Y NAND2X1_38/a_9_6# Gnd nfet w=20 l=2
+  ad=100p pd=50u as=0 ps=0
M2856 gnd INVX2_122/Y AOI22X1_14/a_28_6# Gnd nfet w=20 l=2
+  ad=0 pd=0 as=59.999996p ps=46u
M2857 OR2X1_4/A INVX2_122/Y AOI22X1_14/a_11_6# Gnd nfet w=20 l=2
+  ad=0.2n pd=60u as=59.999996p ps=46u
M2858 AOI22X1_14/a_11_6# AOI22X1_14/A gnd Gnd nfet w=20 l=2
+  ad=0 pd=0 as=0 ps=0
M2859 AOI22X1_14/a_2_54# INVX2_122/Y vdd vdd pfet w=40 l=2
+  ad=0.64n pd=0.272m as=0 ps=0
M2860 AOI22X1_14/a_28_6# OAI21X1_34/Y OR2X1_4/A Gnd nfet w=20 l=2
+  ad=0 pd=0 as=0 ps=0
M2861 vdd AOI22X1_14/A AOI22X1_14/a_2_54# vdd pfet w=40 l=2
+  ad=0 pd=0 as=0 ps=0
M2862 OR2X1_4/A OAI21X1_34/Y AOI22X1_14/a_2_54# vdd pfet w=40 l=2
+  ad=0.24n pd=92u as=0 ps=0
M2863 AOI22X1_14/a_2_54# INVX2_122/Y OR2X1_4/A vdd pfet w=40 l=2
+  ad=0 pd=0 as=0 ps=0
M2864 gnd INVX2_134/Y AOI22X1_36/a_28_6# Gnd nfet w=20 l=2
+  ad=0 pd=0 as=59.999996p ps=46u
M2865 NAND2X1_48/A OAI21X1_98/Y AOI22X1_36/a_11_6# Gnd nfet w=20 l=2
+  ad=0.2n pd=60u as=59.999996p ps=46u
M2866 AOI22X1_36/a_11_6# shield_hp[1] gnd Gnd nfet w=20 l=2
+  ad=0 pd=0 as=0 ps=0
M2867 AOI22X1_36/a_2_54# OAI21X1_98/Y vdd vdd pfet w=40 l=2
+  ad=0.64n pd=0.272m as=0 ps=0
M2868 AOI22X1_36/a_28_6# INVX2_86/Y NAND2X1_48/A Gnd nfet w=20 l=2
+  ad=0 pd=0 as=0 ps=0
M2869 vdd shield_hp[1] AOI22X1_36/a_2_54# vdd pfet w=40 l=2
+  ad=0 pd=0 as=0 ps=0
M2870 NAND2X1_48/A INVX2_86/Y AOI22X1_36/a_2_54# vdd pfet w=40 l=2
+  ad=0.24n pd=92u as=0 ps=0
M2871 AOI22X1_36/a_2_54# INVX2_134/Y NAND2X1_48/A vdd pfet w=40 l=2
+  ad=0 pd=0 as=0 ps=0
M2872 gnd INVX2_159/A AOI22X1_47/a_28_6# Gnd nfet w=20 l=2
+  ad=0 pd=0 as=59.999996p ps=46u
M2873 INVX2_169/A INVX2_168/Y AOI22X1_47/a_11_6# Gnd nfet w=20 l=2
+  ad=0.2n pd=60u as=59.999996p ps=46u
M2874 AOI22X1_47/a_11_6# AOI22X1_47/A gnd Gnd nfet w=20 l=2
+  ad=0 pd=0 as=0 ps=0
M2875 AOI22X1_47/a_2_54# INVX2_168/Y vdd vdd pfet w=40 l=2
+  ad=0.64n pd=0.272m as=0 ps=0
M2876 AOI22X1_47/a_28_6# NOR2X1_54/Y INVX2_169/A Gnd nfet w=20 l=2
+  ad=0 pd=0 as=0 ps=0
M2877 vdd AOI22X1_47/A AOI22X1_47/a_2_54# vdd pfet w=40 l=2
+  ad=0 pd=0 as=0 ps=0
M2878 INVX2_169/A NOR2X1_54/Y AOI22X1_47/a_2_54# vdd pfet w=40 l=2
+  ad=0.24n pd=92u as=0 ps=0
M2879 AOI22X1_47/a_2_54# INVX2_159/A INVX2_169/A vdd pfet w=40 l=2
+  ad=0 pd=0 as=0 ps=0
M2880 gnd NAND2X1_17/Y AOI22X1_25/a_28_6# Gnd nfet w=20 l=2
+  ad=0 pd=0 as=59.999996p ps=46u
M2881 OAI21X1_53/C AND2X2_9/Y AOI22X1_25/a_11_6# Gnd nfet w=20 l=2
+  ad=0.2n pd=60u as=59.999996p ps=46u
M2882 AOI22X1_25/a_11_6# AND2X2_7/Y gnd Gnd nfet w=20 l=2
+  ad=0 pd=0 as=0 ps=0
M2883 AOI22X1_25/a_2_54# AND2X2_9/Y vdd vdd pfet w=40 l=2
+  ad=0.64n pd=0.272m as=0 ps=0
M2884 AOI22X1_25/a_28_6# AND2X2_8/Y OAI21X1_53/C Gnd nfet w=20 l=2
+  ad=0 pd=0 as=0 ps=0
M2885 vdd AND2X2_7/Y AOI22X1_25/a_2_54# vdd pfet w=40 l=2
+  ad=0 pd=0 as=0 ps=0
M2886 OAI21X1_53/C AND2X2_8/Y AOI22X1_25/a_2_54# vdd pfet w=40 l=2
+  ad=0.24n pd=92u as=0 ps=0
M2887 AOI22X1_25/a_2_54# NAND2X1_17/Y OAI21X1_53/C vdd pfet w=40 l=2
+  ad=0 pd=0 as=0 ps=0
M2888 gnd XNOR2X1_5/Y AOI22X1_58/a_28_6# Gnd nfet w=20 l=2
+  ad=0 pd=0 as=59.999996p ps=46u
M2889 NAND2X1_69/A INVX2_106/Y AOI22X1_58/a_11_6# Gnd nfet w=20 l=2
+  ad=0.2n pd=60u as=59.999996p ps=46u
M2890 AOI22X1_58/a_11_6# XNOR2X1_6/Y gnd Gnd nfet w=20 l=2
+  ad=0 pd=0 as=0 ps=0
M2891 AOI22X1_58/a_2_54# INVX2_106/Y vdd vdd pfet w=40 l=2
+  ad=0.64n pd=0.272m as=0 ps=0
M2892 AOI22X1_58/a_28_6# INVX2_106/A NAND2X1_69/A Gnd nfet w=20 l=2
+  ad=0 pd=0 as=0 ps=0
M2893 vdd XNOR2X1_6/Y AOI22X1_58/a_2_54# vdd pfet w=40 l=2
+  ad=0 pd=0 as=0 ps=0
M2894 NAND2X1_69/A INVX2_106/A AOI22X1_58/a_2_54# vdd pfet w=40 l=2
+  ad=0.24n pd=92u as=0 ps=0
M2895 AOI22X1_58/a_2_54# XNOR2X1_5/Y NAND2X1_69/A vdd pfet w=40 l=2
+  ad=0 pd=0 as=0 ps=0
M2896 gnd OAI22X1_9/A OAI22X1_9/a_2_6# Gnd nfet w=20 l=2
+  ad=0 pd=0 as=0.32n ps=0.152m
M2897 OAI22X1_9/a_2_6# OAI22X1_9/C OAI22X1_9/Y Gnd nfet w=20 l=2
+  ad=0 pd=0 as=0.12n ps=52u
M2898 OAI22X1_9/Y OAI22X1_9/D OAI22X1_9/a_2_6# Gnd nfet w=20 l=2
+  ad=0 pd=0 as=0 ps=0
M2899 OAI22X1_9/Y OAI22X1_9/B OAI22X1_9/a_9_54# vdd pfet w=40 l=2
+  ad=0.48n pd=0.104m as=0.12n ps=86u
M2900 OAI22X1_9/a_28_54# OAI22X1_9/D OAI22X1_9/Y vdd pfet w=40 l=2
+  ad=0.12n pd=86u as=0 ps=0
M2901 OAI22X1_9/a_9_54# OAI22X1_9/A vdd vdd pfet w=40 l=2
+  ad=0 pd=0 as=0 ps=0
M2902 OAI22X1_9/a_2_6# OAI22X1_9/B gnd Gnd nfet w=20 l=2
+  ad=0 pd=0 as=0 ps=0
M2903 vdd OAI22X1_9/C OAI22X1_9/a_28_54# vdd pfet w=40 l=2
+  ad=0 pd=0 as=0 ps=0
M2904 INVX2_18/Y player_bullet_coord_x[3] gnd Gnd nfet w=20 l=2
+  ad=100p pd=50u as=0 ps=0
M2905 INVX2_18/Y player_bullet_coord_x[3] vdd vdd pfet w=40 l=2
+  ad=0.2n pd=90u as=0 ps=0
M2906 INVX2_29/Y INVX2_29/A gnd Gnd nfet w=20 l=2
+  ad=100p pd=50u as=0 ps=0
M2907 INVX2_29/Y INVX2_29/A vdd vdd pfet w=40 l=2
+  ad=0.2n pd=90u as=0 ps=0
M2908 gnd player_bullet_coord_x[1] XOR2X1_1/a_2_6# Gnd nfet w=20 l=2
+  ad=0 pd=0 as=100p ps=50u
M2909 XOR2X1_1/Y XOR2X1_1/a_2_6# XOR2X1_1/a_18_6# Gnd nfet w=20 l=2
+  ad=0.2n pd=60u as=59.999996p ps=46u
M2910 XOR2X1_1/a_13_43# player_bullet_coord_x[2] gnd Gnd nfet w=20 l=2
+  ad=100p pd=50u as=0 ps=0
M2911 XOR2X1_1/a_18_54# XOR2X1_1/a_13_43# vdd vdd pfet w=40 l=2
+  ad=0.12n pd=86u as=0 ps=0
M2912 XOR2X1_1/a_35_6# player_bullet_coord_x[1] XOR2X1_1/Y Gnd nfet w=20 l=2
+  ad=59.999996p pd=46u as=0 ps=0
M2913 XOR2X1_1/a_18_6# XOR2X1_1/a_13_43# gnd Gnd nfet w=20 l=2
+  ad=0 pd=0 as=0 ps=0
M2914 vdd player_bullet_coord_x[1] XOR2X1_1/a_2_6# vdd pfet w=40 l=2
+  ad=0 pd=0 as=0.2n ps=90u
M2915 vdd player_bullet_coord_x[2] XOR2X1_1/a_35_54# vdd pfet w=40 l=2
+  ad=0 pd=0 as=0.12n ps=86u
M2916 XOR2X1_1/Y player_bullet_coord_x[1] XOR2X1_1/a_18_54# vdd pfet w=40 l=2
+  ad=0.4n pd=100u as=0 ps=0
M2917 XOR2X1_1/a_35_54# XOR2X1_1/a_2_6# XOR2X1_1/Y vdd pfet w=40 l=2
+  ad=0 pd=0 as=0 ps=0
M2918 XOR2X1_1/a_13_43# player_bullet_coord_x[2] vdd vdd pfet w=40 l=2
+  ad=0.2n pd=90u as=0 ps=0
M2919 gnd player_bullet_coord_x[2] XOR2X1_1/a_35_6# Gnd nfet w=20 l=2
+  ad=0 pd=0 as=0 ps=0
M2920 INVX2_141/Y INVX2_141/A gnd Gnd nfet w=20 l=2
+  ad=100p pd=50u as=0 ps=0
M2921 INVX2_141/Y INVX2_141/A vdd vdd pfet w=40 l=2
+  ad=0.2n pd=90u as=0 ps=0
M2922 OAI22X1_4/D NOR2X1_30/Y gnd Gnd nfet w=20 l=2
+  ad=100p pd=50u as=0 ps=0
M2923 OAI22X1_4/D NOR2X1_30/Y vdd vdd pfet w=40 l=2
+  ad=0.2n pd=90u as=0 ps=0
M2924 INVX2_163/Y INVX2_163/A gnd Gnd nfet w=20 l=2
+  ad=100p pd=50u as=0 ps=0
M2925 INVX2_163/Y INVX2_163/A vdd vdd pfet w=40 l=2
+  ad=0.2n pd=90u as=0 ps=0
M2926 INVX2_152/Y INVX2_152/A gnd Gnd nfet w=20 l=2
+  ad=100p pd=50u as=0 ps=0
M2927 INVX2_152/Y INVX2_152/A vdd vdd pfet w=40 l=2
+  ad=0.2n pd=90u as=0 ps=0
M2928 NAND2X1_1/B OR2X1_15/A gnd Gnd nfet w=20 l=2
+  ad=100p pd=50u as=0 ps=0
M2929 NAND2X1_1/B OR2X1_15/A vdd vdd pfet w=40 l=2
+  ad=0.2n pd=90u as=0 ps=0
M2930 AND2X2_0/A INVX2_185/A gnd Gnd nfet w=20 l=2
+  ad=100p pd=50u as=0 ps=0
M2931 AND2X2_0/A INVX2_185/A vdd vdd pfet w=40 l=2
+  ad=0.2n pd=90u as=0 ps=0
M2932 DFFNEGX1_14/a_76_6# BUFX2_7/Y DFFNEGX1_14/a_66_6# Gnd nfet w=10 l=2
+  ad=29.999998p pd=26u as=80p ps=36u
M2933 gnd BUFX2_7/Y DFFNEGX1_14/a_2_6# Gnd nfet w=20 l=2
+  ad=0 pd=0 as=100p ps=50u
M2934 DFFNEGX1_14/a_66_6# DFFNEGX1_14/a_2_6# DFFNEGX1_14/a_61_6# Gnd nfet w=10 l=2
+  ad=0 pd=0 as=29.999998p ps=26u
M2935 player_bullet_display DFFNEGX1_14/a_66_6# gnd Gnd nfet w=20 l=2
+  ad=100p pd=50u as=0 ps=0
M2936 DFFNEGX1_14/a_23_6# BUFX2_7/Y DFFNEGX1_14/a_17_6# Gnd nfet w=10 l=2
+  ad=59.999996p pd=32u as=40p ps=28u
M2937 DFFNEGX1_14/a_23_6# DFFNEGX1_14/a_2_6# DFFNEGX1_14/a_17_74# vdd pfet w=20 l=2
+  ad=0.12n pd=52u as=80p ps=48u
M2938 gnd DFFNEGX1_14/a_34_4# DFFNEGX1_14/a_31_6# Gnd nfet w=10 l=2
+  ad=0 pd=0 as=29.999998p ps=26u
M2939 vdd DFFNEGX1_14/a_34_4# DFFNEGX1_14/a_31_74# vdd pfet w=20 l=2
+  ad=0 pd=0 as=80p ps=48u
M2940 DFFNEGX1_14/a_61_74# DFFNEGX1_14/a_34_4# vdd vdd pfet w=20 l=2
+  ad=59.999996p pd=46u as=0 ps=0
M2941 DFFNEGX1_14/a_34_4# DFFNEGX1_14/a_23_6# vdd vdd pfet w=20 l=2
+  ad=100p pd=50u as=0 ps=0
M2942 DFFNEGX1_14/a_34_4# DFFNEGX1_14/a_23_6# gnd Gnd nfet w=10 l=2
+  ad=50p pd=30u as=0 ps=0
M2943 vdd player_bullet_display DFFNEGX1_14/a_76_84# vdd pfet w=10 l=2
+  ad=0 pd=0 as=29.999998p ps=26u
M2944 gnd player_bullet_display DFFNEGX1_14/a_76_6# Gnd nfet w=10 l=2
+  ad=0 pd=0 as=0 ps=0
M2945 DFFNEGX1_14/a_61_6# DFFNEGX1_14/a_34_4# gnd Gnd nfet w=10 l=2
+  ad=0 pd=0 as=0 ps=0
M2946 DFFNEGX1_14/a_76_84# DFFNEGX1_14/a_2_6# DFFNEGX1_14/a_66_6# vdd pfet w=10 l=2
+  ad=0 pd=0 as=0.15n ps=56u
M2947 player_bullet_display DFFNEGX1_14/a_66_6# vdd vdd pfet w=40 l=2
+  ad=0.2n pd=90u as=0 ps=0
M2948 vdd BUFX2_7/Y DFFNEGX1_14/a_2_6# vdd pfet w=40 l=2
+  ad=0 pd=0 as=0.2n ps=90u
M2949 DFFNEGX1_14/a_31_6# DFFNEGX1_14/a_2_6# DFFNEGX1_14/a_23_6# Gnd nfet w=10 l=2
+  ad=0 pd=0 as=0 ps=0
M2950 DFFNEGX1_14/a_66_6# BUFX2_7/Y DFFNEGX1_14/a_61_74# vdd pfet w=20 l=2
+  ad=0 pd=0 as=0 ps=0
M2951 DFFNEGX1_14/a_17_74# AND2X2_0/A vdd vdd pfet w=20 l=2
+  ad=0 pd=0 as=0 ps=0
M2952 DFFNEGX1_14/a_31_74# BUFX2_7/Y DFFNEGX1_14/a_23_6# vdd pfet w=20 l=2
+  ad=0 pd=0 as=0 ps=0
M2953 DFFNEGX1_14/a_17_6# AND2X2_0/A gnd Gnd nfet w=10 l=2
+  ad=0 pd=0 as=0 ps=0
M2954 DFFNEGX1_25/a_76_6# BUFX2_6/Y DFFNEGX1_25/a_66_6# Gnd nfet w=10 l=2
+  ad=29.999998p pd=26u as=80p ps=36u
M2955 gnd BUFX2_6/Y DFFNEGX1_25/a_2_6# Gnd nfet w=20 l=2
+  ad=0 pd=0 as=100p ps=50u
M2956 DFFNEGX1_25/a_66_6# DFFNEGX1_25/a_2_6# DFFNEGX1_25/a_61_6# Gnd nfet w=10 l=2
+  ad=0 pd=0 as=29.999998p ps=26u
M2957 INVX2_28/A DFFNEGX1_25/a_66_6# gnd Gnd nfet w=20 l=2
+  ad=100p pd=50u as=0 ps=0
M2958 DFFNEGX1_25/a_23_6# BUFX2_6/Y DFFNEGX1_25/a_17_6# Gnd nfet w=10 l=2
+  ad=59.999996p pd=32u as=40p ps=28u
M2959 DFFNEGX1_25/a_23_6# DFFNEGX1_25/a_2_6# DFFNEGX1_25/a_17_74# vdd pfet w=20 l=2
+  ad=0.12n pd=52u as=80p ps=48u
M2960 gnd DFFNEGX1_25/a_34_4# DFFNEGX1_25/a_31_6# Gnd nfet w=10 l=2
+  ad=0 pd=0 as=29.999998p ps=26u
M2961 vdd DFFNEGX1_25/a_34_4# DFFNEGX1_25/a_31_74# vdd pfet w=20 l=2
+  ad=0 pd=0 as=80p ps=48u
M2962 DFFNEGX1_25/a_61_74# DFFNEGX1_25/a_34_4# vdd vdd pfet w=20 l=2
+  ad=59.999996p pd=46u as=0 ps=0
M2963 DFFNEGX1_25/a_34_4# DFFNEGX1_25/a_23_6# vdd vdd pfet w=20 l=2
+  ad=100p pd=50u as=0 ps=0
M2964 DFFNEGX1_25/a_34_4# DFFNEGX1_25/a_23_6# gnd Gnd nfet w=10 l=2
+  ad=50p pd=30u as=0 ps=0
M2965 vdd INVX2_28/A DFFNEGX1_25/a_76_84# vdd pfet w=10 l=2
+  ad=0 pd=0 as=29.999998p ps=26u
M2966 gnd INVX2_28/A DFFNEGX1_25/a_76_6# Gnd nfet w=10 l=2
+  ad=0 pd=0 as=0 ps=0
M2967 DFFNEGX1_25/a_61_6# DFFNEGX1_25/a_34_4# gnd Gnd nfet w=10 l=2
+  ad=0 pd=0 as=0 ps=0
M2968 DFFNEGX1_25/a_76_84# DFFNEGX1_25/a_2_6# DFFNEGX1_25/a_66_6# vdd pfet w=10 l=2
+  ad=0 pd=0 as=0.15n ps=56u
M2969 INVX2_28/A DFFNEGX1_25/a_66_6# vdd vdd pfet w=40 l=2
+  ad=0.2n pd=90u as=0 ps=0
M2970 vdd BUFX2_6/Y DFFNEGX1_25/a_2_6# vdd pfet w=40 l=2
+  ad=0 pd=0 as=0.2n ps=90u
M2971 DFFNEGX1_25/a_31_6# DFFNEGX1_25/a_2_6# DFFNEGX1_25/a_23_6# Gnd nfet w=10 l=2
+  ad=0 pd=0 as=0 ps=0
M2972 DFFNEGX1_25/a_66_6# BUFX2_6/Y DFFNEGX1_25/a_61_74# vdd pfet w=20 l=2
+  ad=0 pd=0 as=0 ps=0
M2973 DFFNEGX1_25/a_17_74# OAI21X1_57/Y vdd vdd pfet w=20 l=2
+  ad=0 pd=0 as=0 ps=0
M2974 DFFNEGX1_25/a_31_74# BUFX2_6/Y DFFNEGX1_25/a_23_6# vdd pfet w=20 l=2
+  ad=0 pd=0 as=0 ps=0
M2975 DFFNEGX1_25/a_17_6# OAI21X1_57/Y gnd Gnd nfet w=10 l=2
+  ad=0 pd=0 as=0 ps=0
M2976 DFFNEGX1_58/a_76_6# clka DFFNEGX1_58/a_66_6# Gnd nfet w=10 l=2
+  ad=29.999998p pd=26u as=80p ps=36u
M2977 gnd clka DFFNEGX1_58/a_2_6# Gnd nfet w=20 l=2
+  ad=0 pd=0 as=100p ps=50u
M2978 DFFNEGX1_58/a_66_6# DFFNEGX1_58/a_2_6# DFFNEGX1_58/a_61_6# Gnd nfet w=10 l=2
+  ad=0 pd=0 as=29.999998p ps=26u
M2979 INVX2_88/A DFFNEGX1_58/a_66_6# gnd Gnd nfet w=20 l=2
+  ad=100p pd=50u as=0 ps=0
M2980 DFFNEGX1_58/a_23_6# clka DFFNEGX1_58/a_17_6# Gnd nfet w=10 l=2
+  ad=59.999996p pd=32u as=40p ps=28u
M2981 DFFNEGX1_58/a_23_6# DFFNEGX1_58/a_2_6# DFFNEGX1_58/a_17_74# vdd pfet w=20 l=2
+  ad=0.12n pd=52u as=80p ps=48u
M2982 gnd DFFNEGX1_58/a_34_4# DFFNEGX1_58/a_31_6# Gnd nfet w=10 l=2
+  ad=0 pd=0 as=29.999998p ps=26u
M2983 vdd DFFNEGX1_58/a_34_4# DFFNEGX1_58/a_31_74# vdd pfet w=20 l=2
+  ad=0 pd=0 as=80p ps=48u
M2984 DFFNEGX1_58/a_61_74# DFFNEGX1_58/a_34_4# vdd vdd pfet w=20 l=2
+  ad=59.999996p pd=46u as=0 ps=0
M2985 DFFNEGX1_58/a_34_4# DFFNEGX1_58/a_23_6# vdd vdd pfet w=20 l=2
+  ad=100p pd=50u as=0 ps=0
M2986 DFFNEGX1_58/a_34_4# DFFNEGX1_58/a_23_6# gnd Gnd nfet w=10 l=2
+  ad=50p pd=30u as=0 ps=0
M2987 vdd INVX2_88/A DFFNEGX1_58/a_76_84# vdd pfet w=10 l=2
+  ad=0 pd=0 as=29.999998p ps=26u
M2988 gnd INVX2_88/A DFFNEGX1_58/a_76_6# Gnd nfet w=10 l=2
+  ad=0 pd=0 as=0 ps=0
M2989 DFFNEGX1_58/a_61_6# DFFNEGX1_58/a_34_4# gnd Gnd nfet w=10 l=2
+  ad=0 pd=0 as=0 ps=0
M2990 DFFNEGX1_58/a_76_84# DFFNEGX1_58/a_2_6# DFFNEGX1_58/a_66_6# vdd pfet w=10 l=2
+  ad=0 pd=0 as=0.15n ps=56u
M2991 INVX2_88/A DFFNEGX1_58/a_66_6# vdd vdd pfet w=40 l=2
+  ad=0.2n pd=90u as=0 ps=0
M2992 vdd clka DFFNEGX1_58/a_2_6# vdd pfet w=40 l=2
+  ad=0 pd=0 as=0.2n ps=90u
M2993 DFFNEGX1_58/a_31_6# DFFNEGX1_58/a_2_6# DFFNEGX1_58/a_23_6# Gnd nfet w=10 l=2
+  ad=0 pd=0 as=0 ps=0
M2994 DFFNEGX1_58/a_66_6# clka DFFNEGX1_58/a_61_74# vdd pfet w=20 l=2
+  ad=0 pd=0 as=0 ps=0
M2995 DFFNEGX1_58/a_17_74# NOR2X1_40/Y vdd vdd pfet w=20 l=2
+  ad=0 pd=0 as=0 ps=0
M2996 DFFNEGX1_58/a_31_74# clka DFFNEGX1_58/a_23_6# vdd pfet w=20 l=2
+  ad=0 pd=0 as=0 ps=0
M2997 DFFNEGX1_58/a_17_6# NOR2X1_40/Y gnd Gnd nfet w=10 l=2
+  ad=0 pd=0 as=0 ps=0
M2998 DFFNEGX1_36/a_76_6# BUFX2_5/Y DFFNEGX1_36/a_66_6# Gnd nfet w=10 l=2
+  ad=29.999998p pd=26u as=80p ps=36u
M2999 gnd BUFX2_5/Y DFFNEGX1_36/a_2_6# Gnd nfet w=20 l=2
+  ad=0 pd=0 as=100p ps=50u
M3000 DFFNEGX1_36/a_66_6# DFFNEGX1_36/a_2_6# DFFNEGX1_36/a_61_6# Gnd nfet w=10 l=2
+  ad=0 pd=0 as=29.999998p ps=26u
M3001 invader_2_coord_x[3] DFFNEGX1_36/a_66_6# gnd Gnd nfet w=20 l=2
+  ad=100p pd=50u as=0 ps=0
M3002 DFFNEGX1_36/a_23_6# BUFX2_5/Y DFFNEGX1_36/a_17_6# Gnd nfet w=10 l=2
+  ad=59.999996p pd=32u as=40p ps=28u
M3003 DFFNEGX1_36/a_23_6# DFFNEGX1_36/a_2_6# DFFNEGX1_36/a_17_74# vdd pfet w=20 l=2
+  ad=0.12n pd=52u as=80p ps=48u
M3004 gnd DFFNEGX1_36/a_34_4# DFFNEGX1_36/a_31_6# Gnd nfet w=10 l=2
+  ad=0 pd=0 as=29.999998p ps=26u
M3005 vdd DFFNEGX1_36/a_34_4# DFFNEGX1_36/a_31_74# vdd pfet w=20 l=2
+  ad=0 pd=0 as=80p ps=48u
M3006 DFFNEGX1_36/a_61_74# DFFNEGX1_36/a_34_4# vdd vdd pfet w=20 l=2
+  ad=59.999996p pd=46u as=0 ps=0
M3007 DFFNEGX1_36/a_34_4# DFFNEGX1_36/a_23_6# vdd vdd pfet w=20 l=2
+  ad=100p pd=50u as=0 ps=0
M3008 DFFNEGX1_36/a_34_4# DFFNEGX1_36/a_23_6# gnd Gnd nfet w=10 l=2
+  ad=50p pd=30u as=0 ps=0
M3009 vdd invader_2_coord_x[3] DFFNEGX1_36/a_76_84# vdd pfet w=10 l=2
+  ad=0 pd=0 as=29.999998p ps=26u
M3010 gnd invader_2_coord_x[3] DFFNEGX1_36/a_76_6# Gnd nfet w=10 l=2
+  ad=0 pd=0 as=0 ps=0
M3011 DFFNEGX1_36/a_61_6# DFFNEGX1_36/a_34_4# gnd Gnd nfet w=10 l=2
+  ad=0 pd=0 as=0 ps=0
M3012 DFFNEGX1_36/a_76_84# DFFNEGX1_36/a_2_6# DFFNEGX1_36/a_66_6# vdd pfet w=10 l=2
+  ad=0 pd=0 as=0.15n ps=56u
M3013 invader_2_coord_x[3] DFFNEGX1_36/a_66_6# vdd vdd pfet w=40 l=2
+  ad=0.2n pd=90u as=0 ps=0
M3014 vdd BUFX2_5/Y DFFNEGX1_36/a_2_6# vdd pfet w=40 l=2
+  ad=0 pd=0 as=0.2n ps=90u
M3015 DFFNEGX1_36/a_31_6# DFFNEGX1_36/a_2_6# DFFNEGX1_36/a_23_6# Gnd nfet w=10 l=2
+  ad=0 pd=0 as=0 ps=0
M3016 DFFNEGX1_36/a_66_6# BUFX2_5/Y DFFNEGX1_36/a_61_74# vdd pfet w=20 l=2
+  ad=0 pd=0 as=0 ps=0
M3017 DFFNEGX1_36/a_17_74# OAI21X1_58/Y vdd vdd pfet w=20 l=2
+  ad=0 pd=0 as=0 ps=0
M3018 DFFNEGX1_36/a_31_74# BUFX2_5/Y DFFNEGX1_36/a_23_6# vdd pfet w=20 l=2
+  ad=0 pd=0 as=0 ps=0
M3019 DFFNEGX1_36/a_17_6# OAI21X1_58/Y gnd Gnd nfet w=10 l=2
+  ad=0 pd=0 as=0 ps=0
M3020 DFFNEGX1_47/a_76_6# BUFX2_4/Y DFFNEGX1_47/a_66_6# Gnd nfet w=10 l=2
+  ad=29.999998p pd=26u as=80p ps=36u
M3021 gnd BUFX2_4/Y DFFNEGX1_47/a_2_6# Gnd nfet w=20 l=2
+  ad=0 pd=0 as=100p ps=50u
M3022 DFFNEGX1_47/a_66_6# DFFNEGX1_47/a_2_6# DFFNEGX1_47/a_61_6# Gnd nfet w=10 l=2
+  ad=0 pd=0 as=29.999998p ps=26u
M3023 invader_1_coord_x[2] DFFNEGX1_47/a_66_6# gnd Gnd nfet w=20 l=2
+  ad=100p pd=50u as=0 ps=0
M3024 DFFNEGX1_47/a_23_6# BUFX2_4/Y DFFNEGX1_47/a_17_6# Gnd nfet w=10 l=2
+  ad=59.999996p pd=32u as=40p ps=28u
M3025 DFFNEGX1_47/a_23_6# DFFNEGX1_47/a_2_6# DFFNEGX1_47/a_17_74# vdd pfet w=20 l=2
+  ad=0.12n pd=52u as=80p ps=48u
M3026 gnd DFFNEGX1_47/a_34_4# DFFNEGX1_47/a_31_6# Gnd nfet w=10 l=2
+  ad=0 pd=0 as=29.999998p ps=26u
M3027 vdd DFFNEGX1_47/a_34_4# DFFNEGX1_47/a_31_74# vdd pfet w=20 l=2
+  ad=0 pd=0 as=80p ps=48u
M3028 DFFNEGX1_47/a_61_74# DFFNEGX1_47/a_34_4# vdd vdd pfet w=20 l=2
+  ad=59.999996p pd=46u as=0 ps=0
M3029 DFFNEGX1_47/a_34_4# DFFNEGX1_47/a_23_6# vdd vdd pfet w=20 l=2
+  ad=100p pd=50u as=0 ps=0
M3030 DFFNEGX1_47/a_34_4# DFFNEGX1_47/a_23_6# gnd Gnd nfet w=10 l=2
+  ad=50p pd=30u as=0 ps=0
M3031 vdd invader_1_coord_x[2] DFFNEGX1_47/a_76_84# vdd pfet w=10 l=2
+  ad=0 pd=0 as=29.999998p ps=26u
M3032 gnd invader_1_coord_x[2] DFFNEGX1_47/a_76_6# Gnd nfet w=10 l=2
+  ad=0 pd=0 as=0 ps=0
M3033 DFFNEGX1_47/a_61_6# DFFNEGX1_47/a_34_4# gnd Gnd nfet w=10 l=2
+  ad=0 pd=0 as=0 ps=0
M3034 DFFNEGX1_47/a_76_84# DFFNEGX1_47/a_2_6# DFFNEGX1_47/a_66_6# vdd pfet w=10 l=2
+  ad=0 pd=0 as=0.15n ps=56u
M3035 invader_1_coord_x[2] DFFNEGX1_47/a_66_6# vdd vdd pfet w=40 l=2
+  ad=0.2n pd=90u as=0 ps=0
M3036 vdd BUFX2_4/Y DFFNEGX1_47/a_2_6# vdd pfet w=40 l=2
+  ad=0 pd=0 as=0.2n ps=90u
M3037 DFFNEGX1_47/a_31_6# DFFNEGX1_47/a_2_6# DFFNEGX1_47/a_23_6# Gnd nfet w=10 l=2
+  ad=0 pd=0 as=0 ps=0
M3038 DFFNEGX1_47/a_66_6# BUFX2_4/Y DFFNEGX1_47/a_61_74# vdd pfet w=20 l=2
+  ad=0 pd=0 as=0 ps=0
M3039 DFFNEGX1_47/a_17_74# OAI21X1_78/Y vdd vdd pfet w=20 l=2
+  ad=0 pd=0 as=0 ps=0
M3040 DFFNEGX1_47/a_31_74# BUFX2_4/Y DFFNEGX1_47/a_23_6# vdd pfet w=20 l=2
+  ad=0 pd=0 as=0 ps=0
M3041 DFFNEGX1_47/a_17_6# OAI21X1_78/Y gnd Gnd nfet w=10 l=2
+  ad=0 pd=0 as=0 ps=0
M3042 DFFNEGX1_69/a_76_6# BUFX2_3/Y DFFNEGX1_69/a_66_6# Gnd nfet w=10 l=2
+  ad=29.999998p pd=26u as=80p ps=36u
M3043 gnd BUFX2_3/Y DFFNEGX1_69/a_2_6# Gnd nfet w=20 l=2
+  ad=0 pd=0 as=100p ps=50u
M3044 DFFNEGX1_69/a_66_6# DFFNEGX1_69/a_2_6# DFFNEGX1_69/a_61_6# Gnd nfet w=10 l=2
+  ad=0 pd=0 as=29.999998p ps=26u
M3045 NOR2X1_20/B DFFNEGX1_69/a_66_6# gnd Gnd nfet w=20 l=2
+  ad=100p pd=50u as=0 ps=0
M3046 DFFNEGX1_69/a_23_6# BUFX2_3/Y DFFNEGX1_69/a_17_6# Gnd nfet w=10 l=2
+  ad=59.999996p pd=32u as=40p ps=28u
M3047 DFFNEGX1_69/a_23_6# DFFNEGX1_69/a_2_6# DFFNEGX1_69/a_17_74# vdd pfet w=20 l=2
+  ad=0.12n pd=52u as=80p ps=48u
M3048 gnd DFFNEGX1_69/a_34_4# DFFNEGX1_69/a_31_6# Gnd nfet w=10 l=2
+  ad=0 pd=0 as=29.999998p ps=26u
M3049 vdd DFFNEGX1_69/a_34_4# DFFNEGX1_69/a_31_74# vdd pfet w=20 l=2
+  ad=0 pd=0 as=80p ps=48u
M3050 DFFNEGX1_69/a_61_74# DFFNEGX1_69/a_34_4# vdd vdd pfet w=20 l=2
+  ad=59.999996p pd=46u as=0 ps=0
M3051 DFFNEGX1_69/a_34_4# DFFNEGX1_69/a_23_6# vdd vdd pfet w=20 l=2
+  ad=100p pd=50u as=0 ps=0
M3052 DFFNEGX1_69/a_34_4# DFFNEGX1_69/a_23_6# gnd Gnd nfet w=10 l=2
+  ad=50p pd=30u as=0 ps=0
M3053 vdd NOR2X1_20/B DFFNEGX1_69/a_76_84# vdd pfet w=10 l=2
+  ad=0 pd=0 as=29.999998p ps=26u
M3054 gnd NOR2X1_20/B DFFNEGX1_69/a_76_6# Gnd nfet w=10 l=2
+  ad=0 pd=0 as=0 ps=0
M3055 DFFNEGX1_69/a_61_6# DFFNEGX1_69/a_34_4# gnd Gnd nfet w=10 l=2
+  ad=0 pd=0 as=0 ps=0
M3056 DFFNEGX1_69/a_76_84# DFFNEGX1_69/a_2_6# DFFNEGX1_69/a_66_6# vdd pfet w=10 l=2
+  ad=0 pd=0 as=0.15n ps=56u
M3057 NOR2X1_20/B DFFNEGX1_69/a_66_6# vdd vdd pfet w=40 l=2
+  ad=0.2n pd=90u as=0 ps=0
M3058 vdd BUFX2_3/Y DFFNEGX1_69/a_2_6# vdd pfet w=40 l=2
+  ad=0 pd=0 as=0.2n ps=90u
M3059 DFFNEGX1_69/a_31_6# DFFNEGX1_69/a_2_6# DFFNEGX1_69/a_23_6# Gnd nfet w=10 l=2
+  ad=0 pd=0 as=0 ps=0
M3060 DFFNEGX1_69/a_66_6# BUFX2_3/Y DFFNEGX1_69/a_61_74# vdd pfet w=20 l=2
+  ad=0 pd=0 as=0 ps=0
M3061 DFFNEGX1_69/a_17_74# INVX2_131/Y vdd vdd pfet w=20 l=2
+  ad=0 pd=0 as=0 ps=0
M3062 DFFNEGX1_69/a_31_74# BUFX2_3/Y DFFNEGX1_69/a_23_6# vdd pfet w=20 l=2
+  ad=0 pd=0 as=0 ps=0
M3063 DFFNEGX1_69/a_17_6# INVX2_131/Y gnd Gnd nfet w=10 l=2
+  ad=0 pd=0 as=0 ps=0
M3064 gnd INVX2_91/Y XOR2X1_12/a_2_6# Gnd nfet w=20 l=2
+  ad=0 pd=0 as=100p ps=50u
M3065 XOR2X1_12/Y XOR2X1_12/a_2_6# XOR2X1_12/a_18_6# Gnd nfet w=20 l=2
+  ad=0.2n pd=60u as=59.999996p ps=46u
M3066 XOR2X1_12/a_13_43# invader_bullet_coord_y[0] gnd Gnd nfet w=20 l=2
+  ad=100p pd=50u as=0 ps=0
M3067 XOR2X1_12/a_18_54# XOR2X1_12/a_13_43# vdd vdd pfet w=40 l=2
+  ad=0.12n pd=86u as=0 ps=0
M3068 XOR2X1_12/a_35_6# INVX2_91/Y XOR2X1_12/Y Gnd nfet w=20 l=2
+  ad=59.999996p pd=46u as=0 ps=0
M3069 XOR2X1_12/a_18_6# XOR2X1_12/a_13_43# gnd Gnd nfet w=20 l=2
+  ad=0 pd=0 as=0 ps=0
M3070 vdd INVX2_91/Y XOR2X1_12/a_2_6# vdd pfet w=40 l=2
+  ad=0 pd=0 as=0.2n ps=90u
M3071 vdd invader_bullet_coord_y[0] XOR2X1_12/a_35_54# vdd pfet w=40 l=2
+  ad=0 pd=0 as=0.12n ps=86u
M3072 XOR2X1_12/Y INVX2_91/Y XOR2X1_12/a_18_54# vdd pfet w=40 l=2
+  ad=0.4n pd=100u as=0 ps=0
M3073 XOR2X1_12/a_35_54# XOR2X1_12/a_2_6# XOR2X1_12/Y vdd pfet w=40 l=2
+  ad=0 pd=0 as=0 ps=0
M3074 XOR2X1_12/a_13_43# invader_bullet_coord_y[0] vdd vdd pfet w=40 l=2
+  ad=0.2n pd=90u as=0 ps=0
M3075 gnd invader_bullet_coord_y[0] XOR2X1_12/a_35_6# Gnd nfet w=20 l=2
+  ad=0 pd=0 as=0 ps=0
M3076 OAI21X1_8/C OAI21X1_7/C vdd vdd pfet w=20 l=2
+  ad=0.22n pd=0.102m as=0 ps=0
M3077 NAND3X1_2/a_9_6# OAI21X1_7/C gnd Gnd nfet w=30 l=2
+  ad=90p pd=66u as=0 ps=0
M3078 OAI21X1_8/C HAX1_13/YS vdd vdd pfet w=20 l=2
+  ad=0 pd=0 as=0 ps=0
M3079 OAI21X1_8/C HAX1_13/YS NAND3X1_2/a_14_6# Gnd nfet w=30 l=2
+  ad=0.15n pd=70u as=90p ps=66u
M3080 vdd INVX2_15/Y OAI21X1_8/C vdd pfet w=20 l=2
+  ad=0 pd=0 as=0 ps=0
M3081 NAND3X1_2/a_14_6# INVX2_15/Y NAND3X1_2/a_9_6# Gnd nfet w=30 l=2
+  ad=0 pd=0 as=0 ps=0
M3082 gnd INVX2_176/Y OAI21X1_120/a_2_6# Gnd nfet w=20 l=2
+  ad=0 pd=0 as=0.22n ps=0.102m
M3083 vdd OR2X1_17/Y AOI22X1_46/B vdd pfet w=20 l=2
+  ad=0 pd=0 as=0.22n ps=92u
M3084 AOI22X1_46/B OR2X1_17/Y OAI21X1_120/a_2_6# Gnd nfet w=20 l=2
+  ad=100p pd=50u as=0 ps=0
M3085 AOI22X1_46/B NAND2X1_59/Y OAI21X1_120/a_9_54# vdd pfet w=40 l=2
+  ad=0 pd=0 as=0.12n ps=86u
M3086 OAI21X1_120/a_9_54# INVX2_176/Y vdd vdd pfet w=40 l=2
+  ad=0 pd=0 as=0 ps=0
M3087 OAI21X1_120/a_2_6# NAND2X1_59/Y gnd Gnd nfet w=20 l=2
+  ad=0 pd=0 as=0 ps=0
M3088 gnd INVX2_117/A OAI21X1_131/a_2_6# Gnd nfet w=20 l=2
+  ad=0 pd=0 as=0.22n ps=0.102m
M3089 vdd INVX2_116/A NAND3X1_48/B vdd pfet w=20 l=2
+  ad=0 pd=0 as=0.22n ps=92u
M3090 NAND3X1_48/B INVX2_116/A OAI21X1_131/a_2_6# Gnd nfet w=20 l=2
+  ad=100p pd=50u as=0 ps=0
M3091 NAND3X1_48/B OAI21X1_39/B OAI21X1_131/a_9_54# vdd pfet w=40 l=2
+  ad=0 pd=0 as=0.12n ps=86u
M3092 OAI21X1_131/a_9_54# INVX2_117/A vdd vdd pfet w=40 l=2
+  ad=0 pd=0 as=0 ps=0
M3093 OAI21X1_131/a_2_6# OAI21X1_39/B gnd Gnd nfet w=20 l=2
+  ad=0 pd=0 as=0 ps=0
M3094 gnd player_bullet_coord_y[1] AOI22X1_7/a_28_6# Gnd nfet w=20 l=2
+  ad=0 pd=0 as=59.999996p ps=46u
M3095 AOI22X1_7/Y invader_1_coord_y[0] AOI22X1_7/a_11_6# Gnd nfet w=20 l=2
+  ad=0.2n pd=60u as=59.999996p ps=46u
M3096 AOI22X1_7/a_11_6# player_bullet_coord_y[0] gnd Gnd nfet w=20 l=2
+  ad=0 pd=0 as=0 ps=0
M3097 AOI22X1_7/a_2_54# invader_1_coord_y[0] vdd vdd pfet w=40 l=2
+  ad=0.64n pd=0.272m as=0 ps=0
M3098 AOI22X1_7/a_28_6# INVX2_72/Y AOI22X1_7/Y Gnd nfet w=20 l=2
+  ad=0 pd=0 as=0 ps=0
M3099 vdd player_bullet_coord_y[0] AOI22X1_7/a_2_54# vdd pfet w=40 l=2
+  ad=0 pd=0 as=0 ps=0
M3100 AOI22X1_7/Y INVX2_72/Y AOI22X1_7/a_2_54# vdd pfet w=40 l=2
+  ad=0.24n pd=92u as=0 ps=0
M3101 AOI22X1_7/a_2_54# player_bullet_coord_y[1] AOI22X1_7/Y vdd pfet w=40 l=2
+  ad=0 pd=0 as=0 ps=0
M3102 gnd XNOR2X1_6/B OAI21X1_142/a_2_6# Gnd nfet w=20 l=2
+  ad=0 pd=0 as=0.22n ps=0.102m
M3103 vdd NAND2X1_74/Y NAND2X1_73/B vdd pfet w=20 l=2
+  ad=0 pd=0 as=0.22n ps=92u
M3104 NAND2X1_73/B NAND2X1_74/Y OAI21X1_142/a_2_6# Gnd nfet w=20 l=2
+  ad=100p pd=50u as=0 ps=0
M3105 NAND2X1_73/B XNOR2X1_6/A OAI21X1_142/a_9_54# vdd pfet w=40 l=2
+  ad=0 pd=0 as=0.12n ps=86u
M3106 OAI21X1_142/a_9_54# XNOR2X1_6/B vdd vdd pfet w=40 l=2
+  ad=0 pd=0 as=0 ps=0
M3107 OAI21X1_142/a_2_6# XNOR2X1_6/A gnd Gnd nfet w=20 l=2
+  ad=0 pd=0 as=0 ps=0
M3108 gnd invader_1_coord_x[1] OAI21X1_153/a_2_6# Gnd nfet w=20 l=2
+  ad=0 pd=0 as=0.22n ps=0.102m
M3109 vdd OR2X1_17/A OAI21X1_153/Y vdd pfet w=20 l=2
+  ad=0 pd=0 as=0.22n ps=92u
M3110 OAI21X1_153/Y OR2X1_17/A OAI21X1_153/a_2_6# Gnd nfet w=20 l=2
+  ad=100p pd=50u as=0 ps=0
M3111 OAI21X1_153/Y INVX2_100/A OAI21X1_153/a_9_54# vdd pfet w=40 l=2
+  ad=0 pd=0 as=0.12n ps=86u
M3112 OAI21X1_153/a_9_54# invader_1_coord_x[1] vdd vdd pfet w=40 l=2
+  ad=0 pd=0 as=0 ps=0
M3113 OAI21X1_153/a_2_6# INVX2_100/A gnd Gnd nfet w=20 l=2
+  ad=0 pd=0 as=0 ps=0
M3114 OAI21X1_36/C player_coord_x[3] vdd vdd pfet w=20 l=2
+  ad=0.12n pd=52u as=0 ps=0
M3115 NAND2X1_28/a_9_6# player_coord_x[3] gnd Gnd nfet w=20 l=2
+  ad=59.999996p pd=46u as=0 ps=0
M3116 vdd INVX2_9/Y OAI21X1_36/C vdd pfet w=20 l=2
+  ad=0 pd=0 as=0 ps=0
M3117 OAI21X1_36/C INVX2_9/Y NAND2X1_28/a_9_6# Gnd nfet w=20 l=2
+  ad=100p pd=50u as=0 ps=0
M3118 NAND2X1_17/Y NAND2X1_31/Y vdd vdd pfet w=20 l=2
+  ad=0.12n pd=52u as=0 ps=0
M3119 NAND2X1_17/a_9_6# NAND2X1_31/Y gnd Gnd nfet w=20 l=2
+  ad=59.999996p pd=46u as=0 ps=0
M3120 vdd NAND3X1_4/Y NAND2X1_17/Y vdd pfet w=20 l=2
+  ad=0 pd=0 as=0 ps=0
M3121 NAND2X1_17/Y NAND3X1_4/Y NAND2X1_17/a_9_6# Gnd nfet w=20 l=2
+  ad=100p pd=50u as=0 ps=0
M3122 OAI21X1_68/B INVX2_29/A vdd vdd pfet w=20 l=2
+  ad=0.12n pd=52u as=0 ps=0
M3123 NAND2X1_39/a_9_6# INVX2_29/A gnd Gnd nfet w=20 l=2
+  ad=59.999996p pd=46u as=0 ps=0
M3124 vdd INVX2_144/Y OAI21X1_68/B vdd pfet w=20 l=2
+  ad=0 pd=0 as=0 ps=0
M3125 OAI21X1_68/B INVX2_144/Y NAND2X1_39/a_9_6# Gnd nfet w=20 l=2
+  ad=100p pd=50u as=0 ps=0
M3126 gnd invader_bullet_coord_x[1] AOI22X1_15/a_28_6# Gnd nfet w=20 l=2
+  ad=0 pd=0 as=59.999996p ps=46u
M3127 AOI22X1_15/Y player_coord_x[0] AOI22X1_15/a_11_6# Gnd nfet w=20 l=2
+  ad=0.2n pd=60u as=59.999996p ps=46u
M3128 AOI22X1_15/a_11_6# invader_bullet_coord_x[0] gnd Gnd nfet w=20 l=2
+  ad=0 pd=0 as=0 ps=0
M3129 AOI22X1_15/a_2_54# player_coord_x[0] vdd vdd pfet w=40 l=2
+  ad=0.64n pd=0.272m as=0 ps=0
M3130 AOI22X1_15/a_28_6# INVX2_119/Y AOI22X1_15/Y Gnd nfet w=20 l=2
+  ad=0 pd=0 as=0 ps=0
M3131 vdd invader_bullet_coord_x[0] AOI22X1_15/a_2_54# vdd pfet w=40 l=2
+  ad=0 pd=0 as=0 ps=0
M3132 AOI22X1_15/Y INVX2_119/Y AOI22X1_15/a_2_54# vdd pfet w=40 l=2
+  ad=0.24n pd=92u as=0 ps=0
M3133 AOI22X1_15/a_2_54# invader_bullet_coord_x[1] AOI22X1_15/Y vdd pfet w=40 l=2
+  ad=0 pd=0 as=0 ps=0
M3134 gnd AOI22X1_48/C AOI22X1_48/a_28_6# Gnd nfet w=20 l=2
+  ad=0 pd=0 as=59.999996p ps=46u
M3135 INVX2_170/A INVX2_168/Y AOI22X1_48/a_11_6# Gnd nfet w=20 l=2
+  ad=0.2n pd=60u as=59.999996p ps=46u
M3136 AOI22X1_48/a_11_6# AOI22X1_48/A gnd Gnd nfet w=20 l=2
+  ad=0 pd=0 as=0 ps=0
M3137 AOI22X1_48/a_2_54# INVX2_168/Y vdd vdd pfet w=40 l=2
+  ad=0.64n pd=0.272m as=0 ps=0
M3138 AOI22X1_48/a_28_6# NOR2X1_54/Y INVX2_170/A Gnd nfet w=20 l=2
+  ad=0 pd=0 as=0 ps=0
M3139 vdd AOI22X1_48/A AOI22X1_48/a_2_54# vdd pfet w=40 l=2
+  ad=0 pd=0 as=0 ps=0
M3140 INVX2_170/A NOR2X1_54/Y AOI22X1_48/a_2_54# vdd pfet w=40 l=2
+  ad=0.24n pd=92u as=0 ps=0
M3141 AOI22X1_48/a_2_54# AOI22X1_48/C INVX2_170/A vdd pfet w=40 l=2
+  ad=0 pd=0 as=0 ps=0
M3142 gnd OR2X1_12/B AOI22X1_37/a_28_6# Gnd nfet w=20 l=2
+  ad=0 pd=0 as=59.999996p ps=46u
M3143 NOR2X1_40/B INVX2_87/A AOI22X1_37/a_11_6# Gnd nfet w=20 l=2
+  ad=0.2n pd=60u as=59.999996p ps=46u
M3144 AOI22X1_37/a_11_6# NOR2X1_41/Y gnd Gnd nfet w=20 l=2
+  ad=0 pd=0 as=0 ps=0
M3145 AOI22X1_37/a_2_54# INVX2_87/A vdd vdd pfet w=40 l=2
+  ad=0.64n pd=0.272m as=0 ps=0
M3146 AOI22X1_37/a_28_6# INVX2_87/Y NOR2X1_40/B Gnd nfet w=20 l=2
+  ad=0 pd=0 as=0 ps=0
M3147 vdd NOR2X1_41/Y AOI22X1_37/a_2_54# vdd pfet w=40 l=2
+  ad=0 pd=0 as=0 ps=0
M3148 NOR2X1_40/B INVX2_87/Y AOI22X1_37/a_2_54# vdd pfet w=40 l=2
+  ad=0.24n pd=92u as=0 ps=0
M3149 AOI22X1_37/a_2_54# OR2X1_12/B NOR2X1_40/B vdd pfet w=40 l=2
+  ad=0 pd=0 as=0 ps=0
M3150 gnd INVX2_50/Y AOI22X1_26/a_28_6# Gnd nfet w=20 l=2
+  ad=0 pd=0 as=59.999996p ps=46u
M3151 OAI21X1_59/A AND2X2_8/A AOI22X1_26/a_11_6# Gnd nfet w=20 l=2
+  ad=0.2n pd=60u as=59.999996p ps=46u
M3152 AOI22X1_26/a_11_6# INVX2_48/A gnd Gnd nfet w=20 l=2
+  ad=0 pd=0 as=0 ps=0
M3153 AOI22X1_26/a_2_54# AND2X2_8/A vdd vdd pfet w=40 l=2
+  ad=0.64n pd=0.272m as=0 ps=0
M3154 AOI22X1_26/a_28_6# AND2X2_9/B OAI21X1_59/A Gnd nfet w=20 l=2
+  ad=0 pd=0 as=0 ps=0
M3155 vdd INVX2_48/A AOI22X1_26/a_2_54# vdd pfet w=40 l=2
+  ad=0 pd=0 as=0 ps=0
M3156 OAI21X1_59/A AND2X2_9/B AOI22X1_26/a_2_54# vdd pfet w=40 l=2
+  ad=0.24n pd=92u as=0 ps=0
M3157 AOI22X1_26/a_2_54# INVX2_50/Y OAI21X1_59/A vdd pfet w=40 l=2
+  ad=0 pd=0 as=0 ps=0
M3158 gnd XNOR2X1_7/Y AOI22X1_59/a_28_6# Gnd nfet w=20 l=2
+  ad=0 pd=0 as=59.999996p ps=46u
M3159 NAND2X1_70/A INVX2_110/Y AOI22X1_59/a_11_6# Gnd nfet w=20 l=2
+  ad=0.2n pd=60u as=59.999996p ps=46u
M3160 AOI22X1_59/a_11_6# XNOR2X1_8/Y gnd Gnd nfet w=20 l=2
+  ad=0 pd=0 as=0 ps=0
M3161 AOI22X1_59/a_2_54# INVX2_110/Y vdd vdd pfet w=40 l=2
+  ad=0.64n pd=0.272m as=0 ps=0
M3162 AOI22X1_59/a_28_6# INVX2_110/A NAND2X1_70/A Gnd nfet w=20 l=2
+  ad=0 pd=0 as=0 ps=0
M3163 vdd XNOR2X1_8/Y AOI22X1_59/a_2_54# vdd pfet w=40 l=2
+  ad=0 pd=0 as=0 ps=0
M3164 NAND2X1_70/A INVX2_110/A AOI22X1_59/a_2_54# vdd pfet w=40 l=2
+  ad=0.24n pd=92u as=0 ps=0
M3165 AOI22X1_59/a_2_54# XNOR2X1_7/Y NAND2X1_70/A vdd pfet w=40 l=2
+  ad=0 pd=0 as=0 ps=0
M3166 INVX2_19/Y player_bullet_coord_x[2] gnd Gnd nfet w=20 l=2
+  ad=100p pd=50u as=0 ps=0
M3167 INVX2_19/Y player_bullet_coord_x[2] vdd vdd pfet w=40 l=2
+  ad=0.2n pd=90u as=0 ps=0
M3168 gnd XOR2X1_2/A XOR2X1_2/a_2_6# Gnd nfet w=20 l=2
+  ad=0 pd=0 as=100p ps=50u
M3169 XOR2X1_2/Y XOR2X1_2/a_2_6# XOR2X1_2/a_18_6# Gnd nfet w=20 l=2
+  ad=0.2n pd=60u as=59.999996p ps=46u
M3170 XOR2X1_2/a_13_43# invader_bullet_coord_x[3] gnd Gnd nfet w=20 l=2
+  ad=100p pd=50u as=0 ps=0
M3171 XOR2X1_2/a_18_54# XOR2X1_2/a_13_43# vdd vdd pfet w=40 l=2
+  ad=0.12n pd=86u as=0 ps=0
M3172 XOR2X1_2/a_35_6# XOR2X1_2/A XOR2X1_2/Y Gnd nfet w=20 l=2
+  ad=59.999996p pd=46u as=0 ps=0
M3173 XOR2X1_2/a_18_6# XOR2X1_2/a_13_43# gnd Gnd nfet w=20 l=2
+  ad=0 pd=0 as=0 ps=0
M3174 vdd XOR2X1_2/A XOR2X1_2/a_2_6# vdd pfet w=40 l=2
+  ad=0 pd=0 as=0.2n ps=90u
M3175 vdd invader_bullet_coord_x[3] XOR2X1_2/a_35_54# vdd pfet w=40 l=2
+  ad=0 pd=0 as=0.12n ps=86u
M3176 XOR2X1_2/Y XOR2X1_2/A XOR2X1_2/a_18_54# vdd pfet w=40 l=2
+  ad=0.4n pd=100u as=0 ps=0
M3177 XOR2X1_2/a_35_54# XOR2X1_2/a_2_6# XOR2X1_2/Y vdd pfet w=40 l=2
+  ad=0 pd=0 as=0 ps=0
M3178 XOR2X1_2/a_13_43# invader_bullet_coord_x[3] vdd vdd pfet w=40 l=2
+  ad=0.2n pd=90u as=0 ps=0
M3179 gnd invader_bullet_coord_x[3] XOR2X1_2/a_35_6# Gnd nfet w=20 l=2
+  ad=0 pd=0 as=0 ps=0
M3180 INVX2_120/Y HAX1_4/YS gnd Gnd nfet w=20 l=2
+  ad=100p pd=50u as=0 ps=0
M3181 INVX2_120/Y HAX1_4/YS vdd vdd pfet w=40 l=2
+  ad=0.2n pd=90u as=0 ps=0
M3182 INVX2_131/Y INVX2_131/A gnd Gnd nfet w=20 l=2
+  ad=100p pd=50u as=0 ps=0
M3183 INVX2_131/Y INVX2_131/A vdd vdd pfet w=40 l=2
+  ad=0.2n pd=90u as=0 ps=0
M3184 INVX2_164/Y INVX2_164/A gnd Gnd nfet w=20 l=2
+  ad=100p pd=50u as=0 ps=0
M3185 INVX2_164/Y INVX2_164/A vdd vdd pfet w=40 l=2
+  ad=0.2n pd=90u as=0 ps=0
M3186 INVX2_153/Y INVX2_153/A gnd Gnd nfet w=20 l=2
+  ad=100p pd=50u as=0 ps=0
M3187 INVX2_153/Y INVX2_153/A vdd vdd pfet w=40 l=2
+  ad=0.2n pd=90u as=0 ps=0
M3188 INVX2_142/Y INVX2_142/A gnd Gnd nfet w=20 l=2
+  ad=100p pd=50u as=0 ps=0
M3189 INVX2_142/Y INVX2_142/A vdd vdd pfet w=40 l=2
+  ad=0.2n pd=90u as=0 ps=0
M3190 INVX2_175/Y player_coord_x[2] gnd Gnd nfet w=20 l=2
+  ad=100p pd=50u as=0 ps=0
M3191 INVX2_175/Y player_coord_x[2] vdd vdd pfet w=40 l=2
+  ad=0.2n pd=90u as=0 ps=0
M3192 DFFNEGX1_15/a_76_6# BUFX2_6/Y DFFNEGX1_15/a_66_6# Gnd nfet w=10 l=2
+  ad=29.999998p pd=26u as=80p ps=36u
M3193 gnd BUFX2_6/Y DFFNEGX1_15/a_2_6# Gnd nfet w=20 l=2
+  ad=0 pd=0 as=100p ps=50u
M3194 DFFNEGX1_15/a_66_6# DFFNEGX1_15/a_2_6# DFFNEGX1_15/a_61_6# Gnd nfet w=10 l=2
+  ad=0 pd=0 as=29.999998p ps=26u
M3195 INVX2_17/A DFFNEGX1_15/a_66_6# gnd Gnd nfet w=20 l=2
+  ad=100p pd=50u as=0 ps=0
M3196 DFFNEGX1_15/a_23_6# BUFX2_6/Y DFFNEGX1_15/a_17_6# Gnd nfet w=10 l=2
+  ad=59.999996p pd=32u as=40p ps=28u
M3197 DFFNEGX1_15/a_23_6# DFFNEGX1_15/a_2_6# DFFNEGX1_15/a_17_74# vdd pfet w=20 l=2
+  ad=0.12n pd=52u as=80p ps=48u
M3198 gnd DFFNEGX1_15/a_34_4# DFFNEGX1_15/a_31_6# Gnd nfet w=10 l=2
+  ad=0 pd=0 as=29.999998p ps=26u
M3199 vdd DFFNEGX1_15/a_34_4# DFFNEGX1_15/a_31_74# vdd pfet w=20 l=2
+  ad=0 pd=0 as=80p ps=48u
M3200 DFFNEGX1_15/a_61_74# DFFNEGX1_15/a_34_4# vdd vdd pfet w=20 l=2
+  ad=59.999996p pd=46u as=0 ps=0
M3201 DFFNEGX1_15/a_34_4# DFFNEGX1_15/a_23_6# vdd vdd pfet w=20 l=2
+  ad=100p pd=50u as=0 ps=0
M3202 DFFNEGX1_15/a_34_4# DFFNEGX1_15/a_23_6# gnd Gnd nfet w=10 l=2
+  ad=50p pd=30u as=0 ps=0
M3203 vdd INVX2_17/A DFFNEGX1_15/a_76_84# vdd pfet w=10 l=2
+  ad=0 pd=0 as=29.999998p ps=26u
M3204 gnd INVX2_17/A DFFNEGX1_15/a_76_6# Gnd nfet w=10 l=2
+  ad=0 pd=0 as=0 ps=0
M3205 DFFNEGX1_15/a_61_6# DFFNEGX1_15/a_34_4# gnd Gnd nfet w=10 l=2
+  ad=0 pd=0 as=0 ps=0
M3206 DFFNEGX1_15/a_76_84# DFFNEGX1_15/a_2_6# DFFNEGX1_15/a_66_6# vdd pfet w=10 l=2
+  ad=0 pd=0 as=0.15n ps=56u
M3207 INVX2_17/A DFFNEGX1_15/a_66_6# vdd vdd pfet w=40 l=2
+  ad=0.2n pd=90u as=0 ps=0
M3208 vdd BUFX2_6/Y DFFNEGX1_15/a_2_6# vdd pfet w=40 l=2
+  ad=0 pd=0 as=0.2n ps=90u
M3209 DFFNEGX1_15/a_31_6# DFFNEGX1_15/a_2_6# DFFNEGX1_15/a_23_6# Gnd nfet w=10 l=2
+  ad=0 pd=0 as=0 ps=0
M3210 DFFNEGX1_15/a_66_6# BUFX2_6/Y DFFNEGX1_15/a_61_74# vdd pfet w=20 l=2
+  ad=0 pd=0 as=0 ps=0
M3211 DFFNEGX1_15/a_17_74# AND2X2_0/A vdd vdd pfet w=20 l=2
+  ad=0 pd=0 as=0 ps=0
M3212 DFFNEGX1_15/a_31_74# BUFX2_6/Y DFFNEGX1_15/a_23_6# vdd pfet w=20 l=2
+  ad=0 pd=0 as=0 ps=0
M3213 DFFNEGX1_15/a_17_6# AND2X2_0/A gnd Gnd nfet w=10 l=2
+  ad=0 pd=0 as=0 ps=0
M3214 DFFNEGX1_59/a_76_6# BUFX2_4/Y DFFNEGX1_59/a_66_6# Gnd nfet w=10 l=2
+  ad=29.999998p pd=26u as=80p ps=36u
M3215 gnd BUFX2_4/Y DFFNEGX1_59/a_2_6# Gnd nfet w=20 l=2
+  ad=0 pd=0 as=100p ps=50u
M3216 DFFNEGX1_59/a_66_6# DFFNEGX1_59/a_2_6# DFFNEGX1_59/a_61_6# Gnd nfet w=10 l=2
+  ad=0 pd=0 as=29.999998p ps=26u
M3217 OR2X1_12/B DFFNEGX1_59/a_66_6# gnd Gnd nfet w=20 l=2
+  ad=100p pd=50u as=0 ps=0
M3218 DFFNEGX1_59/a_23_6# BUFX2_4/Y DFFNEGX1_59/a_17_6# Gnd nfet w=10 l=2
+  ad=59.999996p pd=32u as=40p ps=28u
M3219 DFFNEGX1_59/a_23_6# DFFNEGX1_59/a_2_6# DFFNEGX1_59/a_17_74# vdd pfet w=20 l=2
+  ad=0.12n pd=52u as=80p ps=48u
M3220 gnd DFFNEGX1_59/a_34_4# DFFNEGX1_59/a_31_6# Gnd nfet w=10 l=2
+  ad=0 pd=0 as=29.999998p ps=26u
M3221 vdd DFFNEGX1_59/a_34_4# DFFNEGX1_59/a_31_74# vdd pfet w=20 l=2
+  ad=0 pd=0 as=80p ps=48u
M3222 DFFNEGX1_59/a_61_74# DFFNEGX1_59/a_34_4# vdd vdd pfet w=20 l=2
+  ad=59.999996p pd=46u as=0 ps=0
M3223 DFFNEGX1_59/a_34_4# DFFNEGX1_59/a_23_6# vdd vdd pfet w=20 l=2
+  ad=100p pd=50u as=0 ps=0
M3224 DFFNEGX1_59/a_34_4# DFFNEGX1_59/a_23_6# gnd Gnd nfet w=10 l=2
+  ad=50p pd=30u as=0 ps=0
M3225 vdd OR2X1_12/B DFFNEGX1_59/a_76_84# vdd pfet w=10 l=2
+  ad=0 pd=0 as=29.999998p ps=26u
M3226 gnd OR2X1_12/B DFFNEGX1_59/a_76_6# Gnd nfet w=10 l=2
+  ad=0 pd=0 as=0 ps=0
M3227 DFFNEGX1_59/a_61_6# DFFNEGX1_59/a_34_4# gnd Gnd nfet w=10 l=2
+  ad=0 pd=0 as=0 ps=0
M3228 DFFNEGX1_59/a_76_84# DFFNEGX1_59/a_2_6# DFFNEGX1_59/a_66_6# vdd pfet w=10 l=2
+  ad=0 pd=0 as=0.15n ps=56u
M3229 OR2X1_12/B DFFNEGX1_59/a_66_6# vdd vdd pfet w=40 l=2
+  ad=0.2n pd=90u as=0 ps=0
M3230 vdd BUFX2_4/Y DFFNEGX1_59/a_2_6# vdd pfet w=40 l=2
+  ad=0 pd=0 as=0.2n ps=90u
M3231 DFFNEGX1_59/a_31_6# DFFNEGX1_59/a_2_6# DFFNEGX1_59/a_23_6# Gnd nfet w=10 l=2
+  ad=0 pd=0 as=0 ps=0
M3232 DFFNEGX1_59/a_66_6# BUFX2_4/Y DFFNEGX1_59/a_61_74# vdd pfet w=20 l=2
+  ad=0 pd=0 as=0 ps=0
M3233 DFFNEGX1_59/a_17_74# NOR2X1_38/Y vdd vdd pfet w=20 l=2
+  ad=0 pd=0 as=0 ps=0
M3234 DFFNEGX1_59/a_31_74# BUFX2_4/Y DFFNEGX1_59/a_23_6# vdd pfet w=20 l=2
+  ad=0 pd=0 as=0 ps=0
M3235 DFFNEGX1_59/a_17_6# NOR2X1_38/Y gnd Gnd nfet w=10 l=2
+  ad=0 pd=0 as=0 ps=0
M3236 DFFNEGX1_37/a_76_6# BUFX2_5/Y DFFNEGX1_37/a_66_6# Gnd nfet w=10 l=2
+  ad=29.999998p pd=26u as=80p ps=36u
M3237 gnd BUFX2_5/Y DFFNEGX1_37/a_2_6# Gnd nfet w=20 l=2
+  ad=0 pd=0 as=100p ps=50u
M3238 DFFNEGX1_37/a_66_6# DFFNEGX1_37/a_2_6# DFFNEGX1_37/a_61_6# Gnd nfet w=10 l=2
+  ad=0 pd=0 as=29.999998p ps=26u
M3239 INVX2_54/A DFFNEGX1_37/a_66_6# gnd Gnd nfet w=20 l=2
+  ad=100p pd=50u as=0 ps=0
M3240 DFFNEGX1_37/a_23_6# BUFX2_5/Y DFFNEGX1_37/a_17_6# Gnd nfet w=10 l=2
+  ad=59.999996p pd=32u as=40p ps=28u
M3241 DFFNEGX1_37/a_23_6# DFFNEGX1_37/a_2_6# DFFNEGX1_37/a_17_74# vdd pfet w=20 l=2
+  ad=0.12n pd=52u as=80p ps=48u
M3242 gnd DFFNEGX1_37/a_34_4# DFFNEGX1_37/a_31_6# Gnd nfet w=10 l=2
+  ad=0 pd=0 as=29.999998p ps=26u
M3243 vdd DFFNEGX1_37/a_34_4# DFFNEGX1_37/a_31_74# vdd pfet w=20 l=2
+  ad=0 pd=0 as=80p ps=48u
M3244 DFFNEGX1_37/a_61_74# DFFNEGX1_37/a_34_4# vdd vdd pfet w=20 l=2
+  ad=59.999996p pd=46u as=0 ps=0
M3245 DFFNEGX1_37/a_34_4# DFFNEGX1_37/a_23_6# vdd vdd pfet w=20 l=2
+  ad=100p pd=50u as=0 ps=0
M3246 DFFNEGX1_37/a_34_4# DFFNEGX1_37/a_23_6# gnd Gnd nfet w=10 l=2
+  ad=50p pd=30u as=0 ps=0
M3247 vdd INVX2_54/A DFFNEGX1_37/a_76_84# vdd pfet w=10 l=2
+  ad=0 pd=0 as=29.999998p ps=26u
M3248 gnd INVX2_54/A DFFNEGX1_37/a_76_6# Gnd nfet w=10 l=2
+  ad=0 pd=0 as=0 ps=0
M3249 DFFNEGX1_37/a_61_6# DFFNEGX1_37/a_34_4# gnd Gnd nfet w=10 l=2
+  ad=0 pd=0 as=0 ps=0
M3250 DFFNEGX1_37/a_76_84# DFFNEGX1_37/a_2_6# DFFNEGX1_37/a_66_6# vdd pfet w=10 l=2
+  ad=0 pd=0 as=0.15n ps=56u
M3251 INVX2_54/A DFFNEGX1_37/a_66_6# vdd vdd pfet w=40 l=2
+  ad=0.2n pd=90u as=0 ps=0
M3252 vdd BUFX2_5/Y DFFNEGX1_37/a_2_6# vdd pfet w=40 l=2
+  ad=0 pd=0 as=0.2n ps=90u
M3253 DFFNEGX1_37/a_31_6# DFFNEGX1_37/a_2_6# DFFNEGX1_37/a_23_6# Gnd nfet w=10 l=2
+  ad=0 pd=0 as=0 ps=0
M3254 DFFNEGX1_37/a_66_6# BUFX2_5/Y DFFNEGX1_37/a_61_74# vdd pfet w=20 l=2
+  ad=0 pd=0 as=0 ps=0
M3255 DFFNEGX1_37/a_17_74# OAI21X1_53/Y vdd vdd pfet w=20 l=2
+  ad=0 pd=0 as=0 ps=0
M3256 DFFNEGX1_37/a_31_74# BUFX2_5/Y DFFNEGX1_37/a_23_6# vdd pfet w=20 l=2
+  ad=0 pd=0 as=0 ps=0
M3257 DFFNEGX1_37/a_17_6# OAI21X1_53/Y gnd Gnd nfet w=10 l=2
+  ad=0 pd=0 as=0 ps=0
M3258 DFFNEGX1_26/a_76_6# BUFX2_6/Y DFFNEGX1_26/a_66_6# Gnd nfet w=10 l=2
+  ad=29.999998p pd=26u as=80p ps=36u
M3259 gnd BUFX2_6/Y DFFNEGX1_26/a_2_6# Gnd nfet w=20 l=2
+  ad=0 pd=0 as=100p ps=50u
M3260 DFFNEGX1_26/a_66_6# DFFNEGX1_26/a_2_6# DFFNEGX1_26/a_61_6# Gnd nfet w=10 l=2
+  ad=0 pd=0 as=29.999998p ps=26u
M3261 OR2X1_20/B DFFNEGX1_26/a_66_6# gnd Gnd nfet w=20 l=2
+  ad=100p pd=50u as=0 ps=0
M3262 DFFNEGX1_26/a_23_6# BUFX2_6/Y DFFNEGX1_26/a_17_6# Gnd nfet w=10 l=2
+  ad=59.999996p pd=32u as=40p ps=28u
M3263 DFFNEGX1_26/a_23_6# DFFNEGX1_26/a_2_6# DFFNEGX1_26/a_17_74# vdd pfet w=20 l=2
+  ad=0.12n pd=52u as=80p ps=48u
M3264 gnd DFFNEGX1_26/a_34_4# DFFNEGX1_26/a_31_6# Gnd nfet w=10 l=2
+  ad=0 pd=0 as=29.999998p ps=26u
M3265 vdd DFFNEGX1_26/a_34_4# DFFNEGX1_26/a_31_74# vdd pfet w=20 l=2
+  ad=0 pd=0 as=80p ps=48u
M3266 DFFNEGX1_26/a_61_74# DFFNEGX1_26/a_34_4# vdd vdd pfet w=20 l=2
+  ad=59.999996p pd=46u as=0 ps=0
M3267 DFFNEGX1_26/a_34_4# DFFNEGX1_26/a_23_6# vdd vdd pfet w=20 l=2
+  ad=100p pd=50u as=0 ps=0
M3268 DFFNEGX1_26/a_34_4# DFFNEGX1_26/a_23_6# gnd Gnd nfet w=10 l=2
+  ad=50p pd=30u as=0 ps=0
M3269 vdd OR2X1_20/B DFFNEGX1_26/a_76_84# vdd pfet w=10 l=2
+  ad=0 pd=0 as=29.999998p ps=26u
M3270 gnd OR2X1_20/B DFFNEGX1_26/a_76_6# Gnd nfet w=10 l=2
+  ad=0 pd=0 as=0 ps=0
M3271 DFFNEGX1_26/a_61_6# DFFNEGX1_26/a_34_4# gnd Gnd nfet w=10 l=2
+  ad=0 pd=0 as=0 ps=0
M3272 DFFNEGX1_26/a_76_84# DFFNEGX1_26/a_2_6# DFFNEGX1_26/a_66_6# vdd pfet w=10 l=2
+  ad=0 pd=0 as=0.15n ps=56u
M3273 OR2X1_20/B DFFNEGX1_26/a_66_6# vdd vdd pfet w=40 l=2
+  ad=0.2n pd=90u as=0 ps=0
M3274 vdd BUFX2_6/Y DFFNEGX1_26/a_2_6# vdd pfet w=40 l=2
+  ad=0 pd=0 as=0.2n ps=90u
M3275 DFFNEGX1_26/a_31_6# DFFNEGX1_26/a_2_6# DFFNEGX1_26/a_23_6# Gnd nfet w=10 l=2
+  ad=0 pd=0 as=0 ps=0
M3276 DFFNEGX1_26/a_66_6# BUFX2_6/Y DFFNEGX1_26/a_61_74# vdd pfet w=20 l=2
+  ad=0 pd=0 as=0 ps=0
M3277 DFFNEGX1_26/a_17_74# OAI21X1_55/Y vdd vdd pfet w=20 l=2
+  ad=0 pd=0 as=0 ps=0
M3278 DFFNEGX1_26/a_31_74# BUFX2_6/Y DFFNEGX1_26/a_23_6# vdd pfet w=20 l=2
+  ad=0 pd=0 as=0 ps=0
M3279 DFFNEGX1_26/a_17_6# OAI21X1_55/Y gnd Gnd nfet w=10 l=2
+  ad=0 pd=0 as=0 ps=0
M3280 DFFNEGX1_48/a_76_6# BUFX2_4/Y DFFNEGX1_48/a_66_6# Gnd nfet w=10 l=2
+  ad=29.999998p pd=26u as=80p ps=36u
M3281 gnd BUFX2_4/Y DFFNEGX1_48/a_2_6# Gnd nfet w=20 l=2
+  ad=0 pd=0 as=100p ps=50u
M3282 DFFNEGX1_48/a_66_6# DFFNEGX1_48/a_2_6# DFFNEGX1_48/a_61_6# Gnd nfet w=10 l=2
+  ad=0 pd=0 as=29.999998p ps=26u
M3283 invader_1_coord_x[3] DFFNEGX1_48/a_66_6# gnd Gnd nfet w=20 l=2
+  ad=100p pd=50u as=0 ps=0
M3284 DFFNEGX1_48/a_23_6# BUFX2_4/Y DFFNEGX1_48/a_17_6# Gnd nfet w=10 l=2
+  ad=59.999996p pd=32u as=40p ps=28u
M3285 DFFNEGX1_48/a_23_6# DFFNEGX1_48/a_2_6# DFFNEGX1_48/a_17_74# vdd pfet w=20 l=2
+  ad=0.12n pd=52u as=80p ps=48u
M3286 gnd DFFNEGX1_48/a_34_4# DFFNEGX1_48/a_31_6# Gnd nfet w=10 l=2
+  ad=0 pd=0 as=29.999998p ps=26u
M3287 vdd DFFNEGX1_48/a_34_4# DFFNEGX1_48/a_31_74# vdd pfet w=20 l=2
+  ad=0 pd=0 as=80p ps=48u
M3288 DFFNEGX1_48/a_61_74# DFFNEGX1_48/a_34_4# vdd vdd pfet w=20 l=2
+  ad=59.999996p pd=46u as=0 ps=0
M3289 DFFNEGX1_48/a_34_4# DFFNEGX1_48/a_23_6# vdd vdd pfet w=20 l=2
+  ad=100p pd=50u as=0 ps=0
M3290 DFFNEGX1_48/a_34_4# DFFNEGX1_48/a_23_6# gnd Gnd nfet w=10 l=2
+  ad=50p pd=30u as=0 ps=0
M3291 vdd invader_1_coord_x[3] DFFNEGX1_48/a_76_84# vdd pfet w=10 l=2
+  ad=0 pd=0 as=29.999998p ps=26u
M3292 gnd invader_1_coord_x[3] DFFNEGX1_48/a_76_6# Gnd nfet w=10 l=2
+  ad=0 pd=0 as=0 ps=0
M3293 DFFNEGX1_48/a_61_6# DFFNEGX1_48/a_34_4# gnd Gnd nfet w=10 l=2
+  ad=0 pd=0 as=0 ps=0
M3294 DFFNEGX1_48/a_76_84# DFFNEGX1_48/a_2_6# DFFNEGX1_48/a_66_6# vdd pfet w=10 l=2
+  ad=0 pd=0 as=0.15n ps=56u
M3295 invader_1_coord_x[3] DFFNEGX1_48/a_66_6# vdd vdd pfet w=40 l=2
+  ad=0.2n pd=90u as=0 ps=0
M3296 vdd BUFX2_4/Y DFFNEGX1_48/a_2_6# vdd pfet w=40 l=2
+  ad=0 pd=0 as=0.2n ps=90u
M3297 DFFNEGX1_48/a_31_6# DFFNEGX1_48/a_2_6# DFFNEGX1_48/a_23_6# Gnd nfet w=10 l=2
+  ad=0 pd=0 as=0 ps=0
M3298 DFFNEGX1_48/a_66_6# BUFX2_4/Y DFFNEGX1_48/a_61_74# vdd pfet w=20 l=2
+  ad=0 pd=0 as=0 ps=0
M3299 DFFNEGX1_48/a_17_74# OAI21X1_77/Y vdd vdd pfet w=20 l=2
+  ad=0 pd=0 as=0 ps=0
M3300 DFFNEGX1_48/a_31_74# BUFX2_4/Y DFFNEGX1_48/a_23_6# vdd pfet w=20 l=2
+  ad=0 pd=0 as=0 ps=0
M3301 DFFNEGX1_48/a_17_6# OAI21X1_77/Y gnd Gnd nfet w=10 l=2
+  ad=0 pd=0 as=0 ps=0
M3302 gnd XOR2X1_13/A XOR2X1_13/a_2_6# Gnd nfet w=20 l=2
+  ad=0 pd=0 as=100p ps=50u
M3303 XOR2X1_13/Y XOR2X1_13/a_2_6# XOR2X1_13/a_18_6# Gnd nfet w=20 l=2
+  ad=0.2n pd=60u as=59.999996p ps=46u
M3304 XOR2X1_13/a_13_43# XOR2X1_15/Y gnd Gnd nfet w=20 l=2
+  ad=100p pd=50u as=0 ps=0
M3305 XOR2X1_13/a_18_54# XOR2X1_13/a_13_43# vdd vdd pfet w=40 l=2
+  ad=0.12n pd=86u as=0 ps=0
M3306 XOR2X1_13/a_35_6# XOR2X1_13/A XOR2X1_13/Y Gnd nfet w=20 l=2
+  ad=59.999996p pd=46u as=0 ps=0
M3307 XOR2X1_13/a_18_6# XOR2X1_13/a_13_43# gnd Gnd nfet w=20 l=2
+  ad=0 pd=0 as=0 ps=0
M3308 vdd XOR2X1_13/A XOR2X1_13/a_2_6# vdd pfet w=40 l=2
+  ad=0 pd=0 as=0.2n ps=90u
M3309 vdd XOR2X1_15/Y XOR2X1_13/a_35_54# vdd pfet w=40 l=2
+  ad=0 pd=0 as=0.12n ps=86u
M3310 XOR2X1_13/Y XOR2X1_13/A XOR2X1_13/a_18_54# vdd pfet w=40 l=2
+  ad=0.4n pd=100u as=0 ps=0
M3311 XOR2X1_13/a_35_54# XOR2X1_13/a_2_6# XOR2X1_13/Y vdd pfet w=40 l=2
+  ad=0 pd=0 as=0 ps=0
M3312 XOR2X1_13/a_13_43# XOR2X1_15/Y vdd vdd pfet w=40 l=2
+  ad=0.2n pd=90u as=0 ps=0
M3313 gnd XOR2X1_15/Y XOR2X1_13/a_35_6# Gnd nfet w=20 l=2
+  ad=0 pd=0 as=0 ps=0
M3314 NAND3X1_3/Y NAND3X1_3/A vdd vdd pfet w=20 l=2
+  ad=0.22n pd=0.102m as=0 ps=0
M3315 NAND3X1_3/a_9_6# NAND3X1_3/A gnd Gnd nfet w=30 l=2
+  ad=90p pd=66u as=0 ps=0
M3316 NAND3X1_3/Y player_bullet_coord_y[2] vdd vdd pfet w=20 l=2
+  ad=0 pd=0 as=0 ps=0
M3317 NAND3X1_3/Y player_bullet_coord_y[2] NAND3X1_3/a_14_6# Gnd nfet w=30 l=2
+  ad=0.15n pd=70u as=90p ps=66u
M3318 vdd INVX2_37/Y NAND3X1_3/Y vdd pfet w=20 l=2
+  ad=0 pd=0 as=0 ps=0
M3319 NAND3X1_3/a_14_6# INVX2_37/Y NAND3X1_3/a_9_6# Gnd nfet w=30 l=2
+  ad=0 pd=0 as=0 ps=0
M3320 gnd player_coord_x[0] OAI21X1_110/a_2_6# Gnd nfet w=20 l=2
+  ad=0 pd=0 as=0.22n ps=0.102m
M3321 vdd NAND2X1_54/Y AOI22X1_42/B vdd pfet w=20 l=2
+  ad=0 pd=0 as=0.22n ps=92u
M3322 AOI22X1_42/B NAND2X1_54/Y OAI21X1_110/a_2_6# Gnd nfet w=20 l=2
+  ad=100p pd=50u as=0 ps=0
M3323 AOI22X1_42/B INVX2_161/A OAI21X1_110/a_9_54# vdd pfet w=40 l=2
+  ad=0 pd=0 as=0.12n ps=86u
M3324 OAI21X1_110/a_9_54# player_coord_x[0] vdd vdd pfet w=40 l=2
+  ad=0 pd=0 as=0 ps=0
M3325 OAI21X1_110/a_2_6# INVX2_161/A gnd Gnd nfet w=20 l=2
+  ad=0 pd=0 as=0 ps=0
M3326 gnd INVX2_97/A OAI21X1_121/a_2_6# Gnd nfet w=20 l=2
+  ad=0 pd=0 as=0.22n ps=0.102m
M3327 vdd NAND2X1_1/B NOR2X1_48/A vdd pfet w=20 l=2
+  ad=0 pd=0 as=0.22n ps=92u
M3328 NOR2X1_48/A NAND2X1_1/B OAI21X1_121/a_2_6# Gnd nfet w=20 l=2
+  ad=100p pd=50u as=0 ps=0
M3329 NOR2X1_48/A NOR2X1_52/Y OAI21X1_121/a_9_54# vdd pfet w=40 l=2
+  ad=0 pd=0 as=0.12n ps=86u
M3330 OAI21X1_121/a_9_54# INVX2_97/A vdd vdd pfet w=40 l=2
+  ad=0 pd=0 as=0 ps=0
M3331 OAI21X1_121/a_2_6# NOR2X1_52/Y gnd Gnd nfet w=20 l=2
+  ad=0 pd=0 as=0 ps=0
M3332 gnd INVX2_128/A OAI21X1_154/a_2_6# Gnd nfet w=20 l=2
+  ad=0 pd=0 as=0.22n ps=0.102m
M3333 vdd INVX2_127/A NOR2X1_54/A vdd pfet w=20 l=2
+  ad=0 pd=0 as=0.22n ps=92u
M3334 NOR2X1_54/A INVX2_127/A OAI21X1_154/a_2_6# Gnd nfet w=20 l=2
+  ad=100p pd=50u as=0 ps=0
M3335 NOR2X1_54/A NOR2X1_60/A OAI21X1_154/a_9_54# vdd pfet w=40 l=2
+  ad=0 pd=0 as=0.12n ps=86u
M3336 OAI21X1_154/a_9_54# INVX2_128/A vdd vdd pfet w=40 l=2
+  ad=0 pd=0 as=0 ps=0
M3337 OAI21X1_154/a_2_6# NOR2X1_60/A gnd Gnd nfet w=20 l=2
+  ad=0 pd=0 as=0 ps=0
M3338 gnd AOI22X1_8/C AOI22X1_8/a_28_6# Gnd nfet w=20 l=2
+  ad=0 pd=0 as=59.999996p ps=46u
M3339 AOI22X1_8/Y INVX2_94/Y AOI22X1_8/a_11_6# Gnd nfet w=20 l=2
+  ad=0.2n pd=60u as=59.999996p ps=46u
M3340 AOI22X1_8/a_11_6# invader_bullet_coord_x[2] gnd Gnd nfet w=20 l=2
+  ad=0 pd=0 as=0 ps=0
M3341 AOI22X1_8/a_2_54# INVX2_94/Y vdd vdd pfet w=40 l=2
+  ad=0.64n pd=0.272m as=0 ps=0
M3342 AOI22X1_8/a_28_6# invader_bullet_coord_x[1] AOI22X1_8/Y Gnd nfet w=20 l=2
+  ad=0 pd=0 as=0 ps=0
M3343 vdd invader_bullet_coord_x[2] AOI22X1_8/a_2_54# vdd pfet w=40 l=2
+  ad=0 pd=0 as=0 ps=0
M3344 AOI22X1_8/Y invader_bullet_coord_x[1] AOI22X1_8/a_2_54# vdd pfet w=40 l=2
+  ad=0.24n pd=92u as=0 ps=0
M3345 AOI22X1_8/a_2_54# AOI22X1_8/C AOI22X1_8/Y vdd pfet w=40 l=2
+  ad=0 pd=0 as=0 ps=0
M3346 gnd player_coord_x[2] OAI21X1_143/a_2_6# Gnd nfet w=20 l=2
+  ad=0 pd=0 as=0.22n ps=0.102m
M3347 vdd NAND2X1_74/Y XNOR2X1_6/B vdd pfet w=20 l=2
+  ad=0 pd=0 as=0.22n ps=92u
M3348 XNOR2X1_6/B NAND2X1_74/Y OAI21X1_143/a_2_6# Gnd nfet w=20 l=2
+  ad=100p pd=50u as=0 ps=0
M3349 XNOR2X1_6/B INVX2_44/Y OAI21X1_143/a_9_54# vdd pfet w=40 l=2
+  ad=0 pd=0 as=0.12n ps=86u
M3350 OAI21X1_143/a_9_54# player_coord_x[2] vdd vdd pfet w=40 l=2
+  ad=0 pd=0 as=0 ps=0
M3351 OAI21X1_143/a_2_6# INVX2_44/Y gnd Gnd nfet w=20 l=2
+  ad=0 pd=0 as=0 ps=0
M3352 gnd INVX2_113/Y OAI21X1_132/a_2_6# Gnd nfet w=20 l=2
+  ad=0 pd=0 as=0.22n ps=0.102m
M3353 vdd OAI21X1_133/Y OAI22X1_8/D vdd pfet w=20 l=2
+  ad=0 pd=0 as=0.22n ps=92u
M3354 OAI22X1_8/D OAI21X1_133/Y OAI21X1_132/a_2_6# Gnd nfet w=20 l=2
+  ad=100p pd=50u as=0 ps=0
M3355 OAI22X1_8/D INVX2_109/A OAI21X1_132/a_9_54# vdd pfet w=40 l=2
+  ad=0 pd=0 as=0.12n ps=86u
M3356 OAI21X1_132/a_9_54# INVX2_113/Y vdd vdd pfet w=40 l=2
+  ad=0 pd=0 as=0 ps=0
M3357 OAI21X1_132/a_2_6# INVX2_109/A gnd Gnd nfet w=20 l=2
+  ad=0 pd=0 as=0 ps=0
M3358 INVX2_173/A shield_coord_x[1] vdd vdd pfet w=20 l=2
+  ad=0.12n pd=52u as=0 ps=0
M3359 NAND2X1_29/a_9_6# shield_coord_x[1] gnd Gnd nfet w=20 l=2
+  ad=59.999996p pd=46u as=0 ps=0
M3360 vdd shield_coord_x[2] INVX2_173/A vdd pfet w=20 l=2
+  ad=0 pd=0 as=0 ps=0
M3361 INVX2_173/A shield_coord_x[2] NAND2X1_29/a_9_6# Gnd nfet w=20 l=2
+  ad=100p pd=50u as=0 ps=0
M3362 NOR2X1_9/A NOR2X1_10/Y vdd vdd pfet w=20 l=2
+  ad=0.12n pd=52u as=0 ps=0
M3363 NAND2X1_18/a_9_6# NOR2X1_10/Y gnd Gnd nfet w=20 l=2
+  ad=59.999996p pd=46u as=0 ps=0
M3364 vdd INVX2_64/Y NOR2X1_9/A vdd pfet w=20 l=2
+  ad=0 pd=0 as=0 ps=0
M3365 NOR2X1_9/A INVX2_64/Y NAND2X1_18/a_9_6# Gnd nfet w=20 l=2
+  ad=100p pd=50u as=0 ps=0
M3366 gnd INVX2_153/A AOI22X1_38/a_28_6# Gnd nfet w=20 l=2
+  ad=0 pd=0 as=59.999996p ps=46u
M3367 NOR2X1_42/A NOR2X1_41/B AOI22X1_38/a_11_6# Gnd nfet w=20 l=2
+  ad=0.2n pd=60u as=59.999996p ps=46u
M3368 AOI22X1_38/a_11_6# INVX2_87/A gnd Gnd nfet w=20 l=2
+  ad=0 pd=0 as=0 ps=0
M3369 AOI22X1_38/a_2_54# NOR2X1_41/B vdd vdd pfet w=40 l=2
+  ad=0.64n pd=0.272m as=0 ps=0
M3370 AOI22X1_38/a_28_6# INVX2_87/Y NOR2X1_42/A Gnd nfet w=20 l=2
+  ad=0 pd=0 as=0 ps=0
M3371 vdd INVX2_87/A AOI22X1_38/a_2_54# vdd pfet w=40 l=2
+  ad=0 pd=0 as=0 ps=0
M3372 NOR2X1_42/A INVX2_87/Y AOI22X1_38/a_2_54# vdd pfet w=40 l=2
+  ad=0.24n pd=92u as=0 ps=0
M3373 AOI22X1_38/a_2_54# INVX2_153/A NOR2X1_42/A vdd pfet w=40 l=2
+  ad=0 pd=0 as=0 ps=0
M3374 gnd INVX2_105/Y AOI22X1_16/a_28_6# Gnd nfet w=20 l=2
+  ad=0 pd=0 as=59.999996p ps=46u
M3375 OR2X1_5/A INVX2_105/Y AOI22X1_16/a_11_6# Gnd nfet w=20 l=2
+  ad=0.2n pd=60u as=59.999996p ps=46u
M3376 AOI22X1_16/a_11_6# AOI22X1_16/A gnd Gnd nfet w=20 l=2
+  ad=0 pd=0 as=0 ps=0
M3377 AOI22X1_16/a_2_54# INVX2_105/Y vdd vdd pfet w=40 l=2
+  ad=0.64n pd=0.272m as=0 ps=0
M3378 AOI22X1_16/a_28_6# OAI21X1_36/Y OR2X1_5/A Gnd nfet w=20 l=2
+  ad=0 pd=0 as=0 ps=0
M3379 vdd AOI22X1_16/A AOI22X1_16/a_2_54# vdd pfet w=40 l=2
+  ad=0 pd=0 as=0 ps=0
M3380 OR2X1_5/A OAI21X1_36/Y AOI22X1_16/a_2_54# vdd pfet w=40 l=2
+  ad=0.24n pd=92u as=0 ps=0
M3381 AOI22X1_16/a_2_54# INVX2_105/Y OR2X1_5/A vdd pfet w=40 l=2
+  ad=0 pd=0 as=0 ps=0
M3382 gnd INVX2_46/A AOI22X1_27/a_28_6# Gnd nfet w=20 l=2
+  ad=0 pd=0 as=59.999996p ps=46u
M3383 NAND2X1_36/B NAND2X1_1/B AOI22X1_27/a_11_6# Gnd nfet w=20 l=2
+  ad=0.2n pd=60u as=59.999996p ps=46u
M3384 AOI22X1_27/a_11_6# INVX2_30/Y gnd Gnd nfet w=20 l=2
+  ad=0 pd=0 as=0 ps=0
M3385 AOI22X1_27/a_2_54# NAND2X1_1/B vdd vdd pfet w=40 l=2
+  ad=0.64n pd=0.272m as=0 ps=0
M3386 AOI22X1_27/a_28_6# AND2X2_9/Y NAND2X1_36/B Gnd nfet w=20 l=2
+  ad=0 pd=0 as=0 ps=0
M3387 vdd INVX2_30/Y AOI22X1_27/a_2_54# vdd pfet w=40 l=2
+  ad=0 pd=0 as=0 ps=0
M3388 NAND2X1_36/B AND2X2_9/Y AOI22X1_27/a_2_54# vdd pfet w=40 l=2
+  ad=0.24n pd=92u as=0 ps=0
M3389 AOI22X1_27/a_2_54# INVX2_46/A NAND2X1_36/B vdd pfet w=40 l=2
+  ad=0 pd=0 as=0 ps=0
M3390 gnd INVX2_158/A AOI22X1_49/a_28_6# Gnd nfet w=20 l=2
+  ad=0 pd=0 as=59.999996p ps=46u
M3391 INVX2_171/A INVX2_168/Y AOI22X1_49/a_11_6# Gnd nfet w=20 l=2
+  ad=0.2n pd=60u as=59.999996p ps=46u
M3392 AOI22X1_49/a_11_6# AOI22X1_49/A gnd Gnd nfet w=20 l=2
+  ad=0 pd=0 as=0 ps=0
M3393 AOI22X1_49/a_2_54# INVX2_168/Y vdd vdd pfet w=40 l=2
+  ad=0.64n pd=0.272m as=0 ps=0
M3394 AOI22X1_49/a_28_6# NOR2X1_54/Y INVX2_171/A Gnd nfet w=20 l=2
+  ad=0 pd=0 as=0 ps=0
M3395 vdd AOI22X1_49/A AOI22X1_49/a_2_54# vdd pfet w=40 l=2
+  ad=0 pd=0 as=0 ps=0
M3396 INVX2_171/A NOR2X1_54/Y AOI22X1_49/a_2_54# vdd pfet w=40 l=2
+  ad=0.24n pd=92u as=0 ps=0
M3397 AOI22X1_49/a_2_54# INVX2_158/A INVX2_171/A vdd pfet w=40 l=2
+  ad=0 pd=0 as=0 ps=0
M3398 gnd NOR2X1_6/Y OAI21X1_0/a_2_6# Gnd nfet w=20 l=2
+  ad=0 pd=0 as=0.22n ps=0.102m
M3399 vdd NOR2X1_5/A INVX2_46/A vdd pfet w=20 l=2
+  ad=0 pd=0 as=0.22n ps=92u
M3400 INVX2_46/A NOR2X1_5/A OAI21X1_0/a_2_6# Gnd nfet w=20 l=2
+  ad=100p pd=50u as=0 ps=0
M3401 INVX2_46/A INVX2_44/Y OAI21X1_0/a_9_54# vdd pfet w=40 l=2
+  ad=0 pd=0 as=0.12n ps=86u
M3402 OAI21X1_0/a_9_54# NOR2X1_6/Y vdd vdd pfet w=40 l=2
+  ad=0 pd=0 as=0 ps=0
M3403 OAI21X1_0/a_2_6# INVX2_44/Y gnd Gnd nfet w=20 l=2
+  ad=0 pd=0 as=0 ps=0
M3404 gnd invader_bullet_coord_x[1] XOR2X1_3/a_2_6# Gnd nfet w=20 l=2
+  ad=0 pd=0 as=100p ps=50u
M3405 INVX2_5/A XOR2X1_3/a_2_6# XOR2X1_3/a_18_6# Gnd nfet w=20 l=2
+  ad=0.2n pd=60u as=59.999996p ps=46u
M3406 XOR2X1_3/a_13_43# invader_bullet_coord_x[2] gnd Gnd nfet w=20 l=2
+  ad=100p pd=50u as=0 ps=0
M3407 XOR2X1_3/a_18_54# XOR2X1_3/a_13_43# vdd vdd pfet w=40 l=2
+  ad=0.12n pd=86u as=0 ps=0
M3408 XOR2X1_3/a_35_6# invader_bullet_coord_x[1] INVX2_5/A Gnd nfet w=20 l=2
+  ad=59.999996p pd=46u as=0 ps=0
M3409 XOR2X1_3/a_18_6# XOR2X1_3/a_13_43# gnd Gnd nfet w=20 l=2
+  ad=0 pd=0 as=0 ps=0
M3410 vdd invader_bullet_coord_x[1] XOR2X1_3/a_2_6# vdd pfet w=40 l=2
+  ad=0 pd=0 as=0.2n ps=90u
M3411 vdd invader_bullet_coord_x[2] XOR2X1_3/a_35_54# vdd pfet w=40 l=2
+  ad=0 pd=0 as=0.12n ps=86u
M3412 INVX2_5/A invader_bullet_coord_x[1] XOR2X1_3/a_18_54# vdd pfet w=40 l=2
+  ad=0.4n pd=100u as=0 ps=0
M3413 XOR2X1_3/a_35_54# XOR2X1_3/a_2_6# INVX2_5/A vdd pfet w=40 l=2
+  ad=0 pd=0 as=0 ps=0
M3414 XOR2X1_3/a_13_43# invader_bullet_coord_x[2] vdd vdd pfet w=40 l=2
+  ad=0.2n pd=90u as=0 ps=0
M3415 gnd invader_bullet_coord_x[2] XOR2X1_3/a_35_6# Gnd nfet w=20 l=2
+  ad=0 pd=0 as=0 ps=0
M3416 INVX2_110/Y INVX2_110/A gnd Gnd nfet w=20 l=2
+  ad=100p pd=50u as=0 ps=0
M3417 INVX2_110/Y INVX2_110/A vdd vdd pfet w=40 l=2
+  ad=0.2n pd=90u as=0 ps=0
M3418 INVX2_132/Y INVX2_132/A gnd Gnd nfet w=20 l=2
+  ad=100p pd=50u as=0 ps=0
M3419 INVX2_132/Y INVX2_132/A vdd vdd pfet w=40 l=2
+  ad=0.2n pd=90u as=0 ps=0
M3420 INVX2_121/Y HAX1_3/YS gnd Gnd nfet w=20 l=2
+  ad=100p pd=50u as=0 ps=0
M3421 INVX2_121/Y HAX1_3/YS vdd vdd pfet w=40 l=2
+  ad=0.2n pd=90u as=0 ps=0
M3422 INVX2_165/Y reset gnd Gnd nfet w=20 l=2
+  ad=100p pd=50u as=0 ps=0
M3423 INVX2_165/Y reset vdd vdd pfet w=40 l=2
+  ad=0.2n pd=90u as=0 ps=0
M3424 INVX2_143/Y INVX2_143/A gnd Gnd nfet w=20 l=2
+  ad=100p pd=50u as=0 ps=0
M3425 INVX2_143/Y INVX2_143/A vdd vdd pfet w=40 l=2
+  ad=0.2n pd=90u as=0 ps=0
M3426 AND2X2_9/B AND2X2_8/A gnd Gnd nfet w=20 l=2
+  ad=100p pd=50u as=0 ps=0
M3427 AND2X2_9/B AND2X2_8/A vdd vdd pfet w=40 l=2
+  ad=0.2n pd=90u as=0 ps=0
M3428 INVX2_176/Y player_coord_x[0] gnd Gnd nfet w=20 l=2
+  ad=100p pd=50u as=0 ps=0
M3429 INVX2_176/Y player_coord_x[0] vdd vdd pfet w=40 l=2
+  ad=0.2n pd=90u as=0 ps=0
M3430 DFFNEGX1_16/a_76_6# BUFX2_6/Y DFFNEGX1_16/a_66_6# Gnd nfet w=10 l=2
+  ad=29.999998p pd=26u as=80p ps=36u
M3431 gnd BUFX2_6/Y DFFNEGX1_16/a_2_6# Gnd nfet w=20 l=2
+  ad=0 pd=0 as=100p ps=50u
M3432 DFFNEGX1_16/a_66_6# DFFNEGX1_16/a_2_6# DFFNEGX1_16/a_61_6# Gnd nfet w=10 l=2
+  ad=0 pd=0 as=29.999998p ps=26u
M3433 player_bullet_coord_x[3] DFFNEGX1_16/a_66_6# gnd Gnd nfet w=20 l=2
+  ad=100p pd=50u as=0 ps=0
M3434 DFFNEGX1_16/a_23_6# BUFX2_6/Y DFFNEGX1_16/a_17_6# Gnd nfet w=10 l=2
+  ad=59.999996p pd=32u as=40p ps=28u
M3435 DFFNEGX1_16/a_23_6# DFFNEGX1_16/a_2_6# DFFNEGX1_16/a_17_74# vdd pfet w=20 l=2
+  ad=0.12n pd=52u as=80p ps=48u
M3436 gnd DFFNEGX1_16/a_34_4# DFFNEGX1_16/a_31_6# Gnd nfet w=10 l=2
+  ad=0 pd=0 as=29.999998p ps=26u
M3437 vdd DFFNEGX1_16/a_34_4# DFFNEGX1_16/a_31_74# vdd pfet w=20 l=2
+  ad=0 pd=0 as=80p ps=48u
M3438 DFFNEGX1_16/a_61_74# DFFNEGX1_16/a_34_4# vdd vdd pfet w=20 l=2
+  ad=59.999996p pd=46u as=0 ps=0
M3439 DFFNEGX1_16/a_34_4# DFFNEGX1_16/a_23_6# vdd vdd pfet w=20 l=2
+  ad=100p pd=50u as=0 ps=0
M3440 DFFNEGX1_16/a_34_4# DFFNEGX1_16/a_23_6# gnd Gnd nfet w=10 l=2
+  ad=50p pd=30u as=0 ps=0
M3441 vdd player_bullet_coord_x[3] DFFNEGX1_16/a_76_84# vdd pfet w=10 l=2
+  ad=0 pd=0 as=29.999998p ps=26u
M3442 gnd player_bullet_coord_x[3] DFFNEGX1_16/a_76_6# Gnd nfet w=10 l=2
+  ad=0 pd=0 as=0 ps=0
M3443 DFFNEGX1_16/a_61_6# DFFNEGX1_16/a_34_4# gnd Gnd nfet w=10 l=2
+  ad=0 pd=0 as=0 ps=0
M3444 DFFNEGX1_16/a_76_84# DFFNEGX1_16/a_2_6# DFFNEGX1_16/a_66_6# vdd pfet w=10 l=2
+  ad=0 pd=0 as=0.15n ps=56u
M3445 player_bullet_coord_x[3] DFFNEGX1_16/a_66_6# vdd vdd pfet w=40 l=2
+  ad=0.2n pd=90u as=0 ps=0
M3446 vdd BUFX2_6/Y DFFNEGX1_16/a_2_6# vdd pfet w=40 l=2
+  ad=0 pd=0 as=0.2n ps=90u
M3447 DFFNEGX1_16/a_31_6# DFFNEGX1_16/a_2_6# DFFNEGX1_16/a_23_6# Gnd nfet w=10 l=2
+  ad=0 pd=0 as=0 ps=0
M3448 DFFNEGX1_16/a_66_6# BUFX2_6/Y DFFNEGX1_16/a_61_74# vdd pfet w=20 l=2
+  ad=0 pd=0 as=0 ps=0
M3449 DFFNEGX1_16/a_17_74# OAI21X1_50/Y vdd vdd pfet w=20 l=2
+  ad=0 pd=0 as=0 ps=0
M3450 DFFNEGX1_16/a_31_74# BUFX2_6/Y DFFNEGX1_16/a_23_6# vdd pfet w=20 l=2
+  ad=0 pd=0 as=0 ps=0
M3451 DFFNEGX1_16/a_17_6# OAI21X1_50/Y gnd Gnd nfet w=10 l=2
+  ad=0 pd=0 as=0 ps=0
M3452 DFFNEGX1_49/a_76_6# BUFX2_4/Y DFFNEGX1_49/a_66_6# Gnd nfet w=10 l=2
+  ad=29.999998p pd=26u as=80p ps=36u
M3453 gnd BUFX2_4/Y DFFNEGX1_49/a_2_6# Gnd nfet w=20 l=2
+  ad=0 pd=0 as=100p ps=50u
M3454 DFFNEGX1_49/a_66_6# DFFNEGX1_49/a_2_6# DFFNEGX1_49/a_61_6# Gnd nfet w=10 l=2
+  ad=0 pd=0 as=29.999998p ps=26u
M3455 invader_1_coord_y[1] DFFNEGX1_49/a_66_6# gnd Gnd nfet w=20 l=2
+  ad=100p pd=50u as=0 ps=0
M3456 DFFNEGX1_49/a_23_6# BUFX2_4/Y DFFNEGX1_49/a_17_6# Gnd nfet w=10 l=2
+  ad=59.999996p pd=32u as=40p ps=28u
M3457 DFFNEGX1_49/a_23_6# DFFNEGX1_49/a_2_6# DFFNEGX1_49/a_17_74# vdd pfet w=20 l=2
+  ad=0.12n pd=52u as=80p ps=48u
M3458 gnd DFFNEGX1_49/a_34_4# DFFNEGX1_49/a_31_6# Gnd nfet w=10 l=2
+  ad=0 pd=0 as=29.999998p ps=26u
M3459 vdd DFFNEGX1_49/a_34_4# DFFNEGX1_49/a_31_74# vdd pfet w=20 l=2
+  ad=0 pd=0 as=80p ps=48u
M3460 DFFNEGX1_49/a_61_74# DFFNEGX1_49/a_34_4# vdd vdd pfet w=20 l=2
+  ad=59.999996p pd=46u as=0 ps=0
M3461 DFFNEGX1_49/a_34_4# DFFNEGX1_49/a_23_6# vdd vdd pfet w=20 l=2
+  ad=100p pd=50u as=0 ps=0
M3462 DFFNEGX1_49/a_34_4# DFFNEGX1_49/a_23_6# gnd Gnd nfet w=10 l=2
+  ad=50p pd=30u as=0 ps=0
M3463 vdd invader_1_coord_y[1] DFFNEGX1_49/a_76_84# vdd pfet w=10 l=2
+  ad=0 pd=0 as=29.999998p ps=26u
M3464 gnd invader_1_coord_y[1] DFFNEGX1_49/a_76_6# Gnd nfet w=10 l=2
+  ad=0 pd=0 as=0 ps=0
M3465 DFFNEGX1_49/a_61_6# DFFNEGX1_49/a_34_4# gnd Gnd nfet w=10 l=2
+  ad=0 pd=0 as=0 ps=0
M3466 DFFNEGX1_49/a_76_84# DFFNEGX1_49/a_2_6# DFFNEGX1_49/a_66_6# vdd pfet w=10 l=2
+  ad=0 pd=0 as=0.15n ps=56u
M3467 invader_1_coord_y[1] DFFNEGX1_49/a_66_6# vdd vdd pfet w=40 l=2
+  ad=0.2n pd=90u as=0 ps=0
M3468 vdd BUFX2_4/Y DFFNEGX1_49/a_2_6# vdd pfet w=40 l=2
+  ad=0 pd=0 as=0.2n ps=90u
M3469 DFFNEGX1_49/a_31_6# DFFNEGX1_49/a_2_6# DFFNEGX1_49/a_23_6# Gnd nfet w=10 l=2
+  ad=0 pd=0 as=0 ps=0
M3470 DFFNEGX1_49/a_66_6# BUFX2_4/Y DFFNEGX1_49/a_61_74# vdd pfet w=20 l=2
+  ad=0 pd=0 as=0 ps=0
M3471 DFFNEGX1_49/a_17_74# OAI21X1_83/Y vdd vdd pfet w=20 l=2
+  ad=0 pd=0 as=0 ps=0
M3472 DFFNEGX1_49/a_31_74# BUFX2_4/Y DFFNEGX1_49/a_23_6# vdd pfet w=20 l=2
+  ad=0 pd=0 as=0 ps=0
M3473 DFFNEGX1_49/a_17_6# OAI21X1_83/Y gnd Gnd nfet w=10 l=2
+  ad=0 pd=0 as=0 ps=0
M3474 DFFNEGX1_27/a_76_6# clka DFFNEGX1_27/a_66_6# Gnd nfet w=10 l=2
+  ad=29.999998p pd=26u as=80p ps=36u
M3475 gnd clka DFFNEGX1_27/a_2_6# Gnd nfet w=20 l=2
+  ad=0 pd=0 as=100p ps=50u
M3476 DFFNEGX1_27/a_66_6# DFFNEGX1_27/a_2_6# DFFNEGX1_27/a_61_6# Gnd nfet w=10 l=2
+  ad=0 pd=0 as=29.999998p ps=26u
M3477 NOR2X1_32/B DFFNEGX1_27/a_66_6# gnd Gnd nfet w=20 l=2
+  ad=100p pd=50u as=0 ps=0
M3478 DFFNEGX1_27/a_23_6# clka DFFNEGX1_27/a_17_6# Gnd nfet w=10 l=2
+  ad=59.999996p pd=32u as=40p ps=28u
M3479 DFFNEGX1_27/a_23_6# DFFNEGX1_27/a_2_6# DFFNEGX1_27/a_17_74# vdd pfet w=20 l=2
+  ad=0.12n pd=52u as=80p ps=48u
M3480 gnd DFFNEGX1_27/a_34_4# DFFNEGX1_27/a_31_6# Gnd nfet w=10 l=2
+  ad=0 pd=0 as=29.999998p ps=26u
M3481 vdd DFFNEGX1_27/a_34_4# DFFNEGX1_27/a_31_74# vdd pfet w=20 l=2
+  ad=0 pd=0 as=80p ps=48u
M3482 DFFNEGX1_27/a_61_74# DFFNEGX1_27/a_34_4# vdd vdd pfet w=20 l=2
+  ad=59.999996p pd=46u as=0 ps=0
M3483 DFFNEGX1_27/a_34_4# DFFNEGX1_27/a_23_6# vdd vdd pfet w=20 l=2
+  ad=100p pd=50u as=0 ps=0
M3484 DFFNEGX1_27/a_34_4# DFFNEGX1_27/a_23_6# gnd Gnd nfet w=10 l=2
+  ad=50p pd=30u as=0 ps=0
M3485 vdd NOR2X1_32/B DFFNEGX1_27/a_76_84# vdd pfet w=10 l=2
+  ad=0 pd=0 as=29.999998p ps=26u
M3486 gnd NOR2X1_32/B DFFNEGX1_27/a_76_6# Gnd nfet w=10 l=2
+  ad=0 pd=0 as=0 ps=0
M3487 DFFNEGX1_27/a_61_6# DFFNEGX1_27/a_34_4# gnd Gnd nfet w=10 l=2
+  ad=0 pd=0 as=0 ps=0
M3488 DFFNEGX1_27/a_76_84# DFFNEGX1_27/a_2_6# DFFNEGX1_27/a_66_6# vdd pfet w=10 l=2
+  ad=0 pd=0 as=0.15n ps=56u
M3489 NOR2X1_32/B DFFNEGX1_27/a_66_6# vdd vdd pfet w=40 l=2
+  ad=0.2n pd=90u as=0 ps=0
M3490 vdd clka DFFNEGX1_27/a_2_6# vdd pfet w=40 l=2
+  ad=0 pd=0 as=0.2n ps=90u
M3491 DFFNEGX1_27/a_31_6# DFFNEGX1_27/a_2_6# DFFNEGX1_27/a_23_6# Gnd nfet w=10 l=2
+  ad=0 pd=0 as=0 ps=0
M3492 DFFNEGX1_27/a_66_6# clka DFFNEGX1_27/a_61_74# vdd pfet w=20 l=2
+  ad=0 pd=0 as=0 ps=0
M3493 DFFNEGX1_27/a_17_74# OAI21X1_70/Y vdd vdd pfet w=20 l=2
+  ad=0 pd=0 as=0 ps=0
M3494 DFFNEGX1_27/a_31_74# clka DFFNEGX1_27/a_23_6# vdd pfet w=20 l=2
+  ad=0 pd=0 as=0 ps=0
M3495 DFFNEGX1_27/a_17_6# OAI21X1_70/Y gnd Gnd nfet w=10 l=2
+  ad=0 pd=0 as=0 ps=0
M3496 DFFNEGX1_38/a_76_6# BUFX2_5/Y DFFNEGX1_38/a_66_6# Gnd nfet w=10 l=2
+  ad=29.999998p pd=26u as=80p ps=36u
M3497 gnd BUFX2_5/Y DFFNEGX1_38/a_2_6# Gnd nfet w=20 l=2
+  ad=0 pd=0 as=100p ps=50u
M3498 DFFNEGX1_38/a_66_6# DFFNEGX1_38/a_2_6# DFFNEGX1_38/a_61_6# Gnd nfet w=10 l=2
+  ad=0 pd=0 as=29.999998p ps=26u
M3499 invader_1_coord_x[0] DFFNEGX1_38/a_66_6# gnd Gnd nfet w=20 l=2
+  ad=100p pd=50u as=0 ps=0
M3500 DFFNEGX1_38/a_23_6# BUFX2_5/Y DFFNEGX1_38/a_17_6# Gnd nfet w=10 l=2
+  ad=59.999996p pd=32u as=40p ps=28u
M3501 DFFNEGX1_38/a_23_6# DFFNEGX1_38/a_2_6# DFFNEGX1_38/a_17_74# vdd pfet w=20 l=2
+  ad=0.12n pd=52u as=80p ps=48u
M3502 gnd DFFNEGX1_38/a_34_4# DFFNEGX1_38/a_31_6# Gnd nfet w=10 l=2
+  ad=0 pd=0 as=29.999998p ps=26u
M3503 vdd DFFNEGX1_38/a_34_4# DFFNEGX1_38/a_31_74# vdd pfet w=20 l=2
+  ad=0 pd=0 as=80p ps=48u
M3504 DFFNEGX1_38/a_61_74# DFFNEGX1_38/a_34_4# vdd vdd pfet w=20 l=2
+  ad=59.999996p pd=46u as=0 ps=0
M3505 DFFNEGX1_38/a_34_4# DFFNEGX1_38/a_23_6# vdd vdd pfet w=20 l=2
+  ad=100p pd=50u as=0 ps=0
M3506 DFFNEGX1_38/a_34_4# DFFNEGX1_38/a_23_6# gnd Gnd nfet w=10 l=2
+  ad=50p pd=30u as=0 ps=0
M3507 vdd invader_1_coord_x[0] DFFNEGX1_38/a_76_84# vdd pfet w=10 l=2
+  ad=0 pd=0 as=29.999998p ps=26u
M3508 gnd invader_1_coord_x[0] DFFNEGX1_38/a_76_6# Gnd nfet w=10 l=2
+  ad=0 pd=0 as=0 ps=0
M3509 DFFNEGX1_38/a_61_6# DFFNEGX1_38/a_34_4# gnd Gnd nfet w=10 l=2
+  ad=0 pd=0 as=0 ps=0
M3510 DFFNEGX1_38/a_76_84# DFFNEGX1_38/a_2_6# DFFNEGX1_38/a_66_6# vdd pfet w=10 l=2
+  ad=0 pd=0 as=0.15n ps=56u
M3511 invader_1_coord_x[0] DFFNEGX1_38/a_66_6# vdd vdd pfet w=40 l=2
+  ad=0.2n pd=90u as=0 ps=0
M3512 vdd BUFX2_5/Y DFFNEGX1_38/a_2_6# vdd pfet w=40 l=2
+  ad=0 pd=0 as=0.2n ps=90u
M3513 DFFNEGX1_38/a_31_6# DFFNEGX1_38/a_2_6# DFFNEGX1_38/a_23_6# Gnd nfet w=10 l=2
+  ad=0 pd=0 as=0 ps=0
M3514 DFFNEGX1_38/a_66_6# BUFX2_5/Y DFFNEGX1_38/a_61_74# vdd pfet w=20 l=2
+  ad=0 pd=0 as=0 ps=0
M3515 DFFNEGX1_38/a_17_74# OAI21X1_86/Y vdd vdd pfet w=20 l=2
+  ad=0 pd=0 as=0 ps=0
M3516 DFFNEGX1_38/a_31_74# BUFX2_5/Y DFFNEGX1_38/a_23_6# vdd pfet w=20 l=2
+  ad=0 pd=0 as=0 ps=0
M3517 DFFNEGX1_38/a_17_6# OAI21X1_86/Y gnd Gnd nfet w=10 l=2
+  ad=0 pd=0 as=0 ps=0
M3518 gnd INVX2_99/Y XOR2X1_14/a_2_6# Gnd nfet w=20 l=2
+  ad=0 pd=0 as=100p ps=50u
M3519 XOR2X1_14/Y XOR2X1_14/a_2_6# XOR2X1_14/a_18_6# Gnd nfet w=20 l=2
+  ad=0.2n pd=60u as=59.999996p ps=46u
M3520 XOR2X1_14/a_13_43# XOR2X1_15/Y gnd Gnd nfet w=20 l=2
+  ad=100p pd=50u as=0 ps=0
M3521 XOR2X1_14/a_18_54# XOR2X1_14/a_13_43# vdd vdd pfet w=40 l=2
+  ad=0.12n pd=86u as=0 ps=0
M3522 XOR2X1_14/a_35_6# INVX2_99/Y XOR2X1_14/Y Gnd nfet w=20 l=2
+  ad=59.999996p pd=46u as=0 ps=0
M3523 XOR2X1_14/a_18_6# XOR2X1_14/a_13_43# gnd Gnd nfet w=20 l=2
+  ad=0 pd=0 as=0 ps=0
M3524 vdd INVX2_99/Y XOR2X1_14/a_2_6# vdd pfet w=40 l=2
+  ad=0 pd=0 as=0.2n ps=90u
M3525 vdd XOR2X1_15/Y XOR2X1_14/a_35_54# vdd pfet w=40 l=2
+  ad=0 pd=0 as=0.12n ps=86u
M3526 XOR2X1_14/Y INVX2_99/Y XOR2X1_14/a_18_54# vdd pfet w=40 l=2
+  ad=0.4n pd=100u as=0 ps=0
M3527 XOR2X1_14/a_35_54# XOR2X1_14/a_2_6# XOR2X1_14/Y vdd pfet w=40 l=2
+  ad=0 pd=0 as=0 ps=0
M3528 XOR2X1_14/a_13_43# XOR2X1_15/Y vdd vdd pfet w=40 l=2
+  ad=0.2n pd=90u as=0 ps=0
M3529 gnd XOR2X1_15/Y XOR2X1_14/a_35_6# Gnd nfet w=20 l=2
+  ad=0 pd=0 as=0 ps=0
M3530 NAND3X1_4/Y XOR2X1_8/Y vdd vdd pfet w=20 l=2
+  ad=0.22n pd=0.102m as=0 ps=0
M3531 NAND3X1_4/a_9_6# XOR2X1_8/Y gnd Gnd nfet w=30 l=2
+  ad=90p pd=66u as=0 ps=0
M3532 NAND3X1_4/Y XOR2X1_7/Y vdd vdd pfet w=20 l=2
+  ad=0 pd=0 as=0 ps=0
M3533 NAND3X1_4/Y XOR2X1_7/Y NAND3X1_4/a_14_6# Gnd nfet w=30 l=2
+  ad=0.15n pd=70u as=90p ps=66u
M3534 vdd OAI22X1_7/B NAND3X1_4/Y vdd pfet w=20 l=2
+  ad=0 pd=0 as=0 ps=0
M3535 NAND3X1_4/a_14_6# OAI22X1_7/B NAND3X1_4/a_9_6# Gnd nfet w=30 l=2
+  ad=0 pd=0 as=0 ps=0
M3536 gnd INVX2_182/Y OAI21X1_111/a_2_6# Gnd nfet w=20 l=2
+  ad=0 pd=0 as=0.22n ps=0.102m
M3537 vdd INVX2_158/Y NOR2X1_45/B vdd pfet w=20 l=2
+  ad=0 pd=0 as=0.22n ps=92u
M3538 NOR2X1_45/B INVX2_158/Y OAI21X1_111/a_2_6# Gnd nfet w=20 l=2
+  ad=100p pd=50u as=0 ps=0
M3539 NOR2X1_45/B OAI21X1_112/Y OAI21X1_111/a_9_54# vdd pfet w=40 l=2
+  ad=0 pd=0 as=0.12n ps=86u
M3540 OAI21X1_111/a_9_54# INVX2_182/Y vdd vdd pfet w=40 l=2
+  ad=0 pd=0 as=0 ps=0
M3541 OAI21X1_111/a_2_6# OAI21X1_112/Y gnd Gnd nfet w=20 l=2
+  ad=0 pd=0 as=0 ps=0
M3542 gnd OR2X1_13/Y OAI21X1_100/a_2_6# Gnd nfet w=20 l=2
+  ad=0 pd=0 as=0.22n ps=0.102m
M3543 vdd AND2X2_18/Y OAI21X1_99/B vdd pfet w=20 l=2
+  ad=0 pd=0 as=0.22n ps=92u
M3544 OAI21X1_99/B AND2X2_18/Y OAI21X1_100/a_2_6# Gnd nfet w=20 l=2
+  ad=100p pd=50u as=0 ps=0
M3545 OAI21X1_99/B INVX2_89/A OAI21X1_100/a_9_54# vdd pfet w=40 l=2
+  ad=0 pd=0 as=0.12n ps=86u
M3546 OAI21X1_100/a_9_54# OR2X1_13/Y vdd vdd pfet w=40 l=2
+  ad=0 pd=0 as=0 ps=0
M3547 OAI21X1_100/a_2_6# INVX2_89/A gnd Gnd nfet w=20 l=2
+  ad=0 pd=0 as=0 ps=0
M3548 gnd reset OAI21X1_122/a_2_6# Gnd nfet w=20 l=2
+  ad=0 pd=0 as=0.22n ps=0.102m
M3549 vdd INVX2_166/A OAI21X1_122/Y vdd pfet w=20 l=2
+  ad=0 pd=0 as=0.22n ps=92u
M3550 OAI21X1_122/Y INVX2_166/A OAI21X1_122/a_2_6# Gnd nfet w=20 l=2
+  ad=100p pd=50u as=0 ps=0
M3551 OAI21X1_122/Y INVX2_152/Y OAI21X1_122/a_9_54# vdd pfet w=40 l=2
+  ad=0 pd=0 as=0.12n ps=86u
M3552 OAI21X1_122/a_9_54# reset vdd vdd pfet w=40 l=2
+  ad=0 pd=0 as=0 ps=0
M3553 OAI21X1_122/a_2_6# INVX2_152/Y gnd Gnd nfet w=20 l=2
+  ad=0 pd=0 as=0 ps=0
M3554 gnd AOI22X1_9/C AOI22X1_9/a_28_6# Gnd nfet w=20 l=2
+  ad=0 pd=0 as=59.999996p ps=46u
M3555 AOI22X1_9/Y INVX2_92/Y AOI22X1_9/a_11_6# Gnd nfet w=20 l=2
+  ad=0.2n pd=60u as=59.999996p ps=46u
M3556 AOI22X1_9/a_11_6# INVX2_5/A gnd Gnd nfet w=20 l=2
+  ad=0 pd=0 as=0 ps=0
M3557 AOI22X1_9/a_2_54# INVX2_92/Y vdd vdd pfet w=40 l=2
+  ad=0.64n pd=0.272m as=0 ps=0
M3558 AOI22X1_9/a_28_6# AOI22X1_9/D AOI22X1_9/Y Gnd nfet w=20 l=2
+  ad=0 pd=0 as=0 ps=0
M3559 vdd INVX2_5/A AOI22X1_9/a_2_54# vdd pfet w=40 l=2
+  ad=0 pd=0 as=0 ps=0
M3560 AOI22X1_9/Y AOI22X1_9/D AOI22X1_9/a_2_54# vdd pfet w=40 l=2
+  ad=0.24n pd=92u as=0 ps=0
M3561 AOI22X1_9/a_2_54# AOI22X1_9/C AOI22X1_9/Y vdd pfet w=40 l=2
+  ad=0 pd=0 as=0 ps=0
M3562 gnd INVX2_99/Y OAI21X1_144/a_2_6# Gnd nfet w=20 l=2
+  ad=0 pd=0 as=0.22n ps=0.102m
M3563 vdd OAI21X1_145/Y XNOR2X1_6/A vdd pfet w=20 l=2
+  ad=0 pd=0 as=0.22n ps=92u
M3564 XNOR2X1_6/A OAI21X1_145/Y OAI21X1_144/a_2_6# Gnd nfet w=20 l=2
+  ad=100p pd=50u as=0 ps=0
M3565 XNOR2X1_6/A OAI22X1_7/B OAI21X1_144/a_9_54# vdd pfet w=40 l=2
+  ad=0 pd=0 as=0.12n ps=86u
M3566 OAI21X1_144/a_9_54# INVX2_99/Y vdd vdd pfet w=40 l=2
+  ad=0 pd=0 as=0 ps=0
M3567 OAI21X1_144/a_2_6# OAI22X1_7/B gnd Gnd nfet w=20 l=2
+  ad=0 pd=0 as=0 ps=0
M3568 gnd INVX2_109/Y OAI21X1_133/a_2_6# Gnd nfet w=20 l=2
+  ad=0 pd=0 as=0.22n ps=0.102m
M3569 vdd OAI21X1_134/Y OAI21X1_133/Y vdd pfet w=20 l=2
+  ad=0 pd=0 as=0.22n ps=92u
M3570 OAI21X1_133/Y OAI21X1_134/Y OAI21X1_133/a_2_6# Gnd nfet w=20 l=2
+  ad=100p pd=50u as=0 ps=0
M3571 OAI21X1_133/Y INVX2_113/A OAI21X1_133/a_9_54# vdd pfet w=40 l=2
+  ad=0 pd=0 as=0.12n ps=86u
M3572 OAI21X1_133/a_9_54# INVX2_109/Y vdd vdd pfet w=40 l=2
+  ad=0 pd=0 as=0 ps=0
M3573 OAI21X1_133/a_2_6# INVX2_113/A gnd Gnd nfet w=20 l=2
+  ad=0 pd=0 as=0 ps=0
M3574 NAND3X1_5/A player_bullet_coord_x[3] vdd vdd pfet w=20 l=2
+  ad=0.12n pd=52u as=0 ps=0
M3575 NAND2X1_19/a_9_6# player_bullet_coord_x[3] gnd Gnd nfet w=20 l=2
+  ad=59.999996p pd=46u as=0 ps=0
M3576 vdd INVX2_66/Y NAND3X1_5/A vdd pfet w=20 l=2
+  ad=0 pd=0 as=0 ps=0
M3577 NAND3X1_5/A INVX2_66/Y NAND2X1_19/a_9_6# Gnd nfet w=20 l=2
+  ad=100p pd=50u as=0 ps=0
M3578 gnd player_coord_x[3] AOI22X1_39/a_28_6# Gnd nfet w=20 l=2
+  ad=0 pd=0 as=59.999996p ps=46u
M3579 NOR2X1_44/B NOR2X1_45/Y AOI22X1_39/a_11_6# Gnd nfet w=20 l=2
+  ad=0.2n pd=60u as=59.999996p ps=46u
M3580 AOI22X1_39/a_11_6# HAX1_3/YS gnd Gnd nfet w=20 l=2
+  ad=0 pd=0 as=0 ps=0
M3581 AOI22X1_39/a_2_54# NOR2X1_45/Y vdd vdd pfet w=40 l=2
+  ad=0.64n pd=0.272m as=0 ps=0
M3582 AOI22X1_39/a_28_6# AOI22X1_39/D NOR2X1_44/B Gnd nfet w=20 l=2
+  ad=0 pd=0 as=0 ps=0
M3583 vdd HAX1_3/YS AOI22X1_39/a_2_54# vdd pfet w=40 l=2
+  ad=0 pd=0 as=0 ps=0
M3584 NOR2X1_44/B AOI22X1_39/D AOI22X1_39/a_2_54# vdd pfet w=40 l=2
+  ad=0.24n pd=92u as=0 ps=0
M3585 AOI22X1_39/a_2_54# player_coord_x[3] NOR2X1_44/B vdd pfet w=40 l=2
+  ad=0 pd=0 as=0 ps=0
M3586 gnd player_coord_x[1] AOI22X1_17/a_28_6# Gnd nfet w=20 l=2
+  ad=0 pd=0 as=59.999996p ps=46u
M3587 AOI22X1_17/Y invader_bullet_coord_x[0] AOI22X1_17/a_11_6# Gnd nfet w=20 l=2
+  ad=0.2n pd=60u as=59.999996p ps=46u
M3588 AOI22X1_17/a_11_6# player_coord_x[0] gnd Gnd nfet w=20 l=2
+  ad=0 pd=0 as=0 ps=0
M3589 AOI22X1_17/a_2_54# invader_bullet_coord_x[0] vdd vdd pfet w=40 l=2
+  ad=0.64n pd=0.272m as=0 ps=0
M3590 AOI22X1_17/a_28_6# INVX2_8/Y AOI22X1_17/Y Gnd nfet w=20 l=2
+  ad=0 pd=0 as=0 ps=0
M3591 vdd player_coord_x[0] AOI22X1_17/a_2_54# vdd pfet w=40 l=2
+  ad=0 pd=0 as=0 ps=0
M3592 AOI22X1_17/Y INVX2_8/Y AOI22X1_17/a_2_54# vdd pfet w=40 l=2
+  ad=0.24n pd=92u as=0 ps=0
M3593 AOI22X1_17/a_2_54# player_coord_x[1] AOI22X1_17/Y vdd pfet w=40 l=2
+  ad=0 pd=0 as=0 ps=0
M3594 gnd NOR2X1_29/B AOI22X1_28/a_28_6# Gnd nfet w=20 l=2
+  ad=0 pd=0 as=59.999996p ps=46u
M3595 NAND2X1_36/A AND2X2_8/Y AOI22X1_28/a_11_6# Gnd nfet w=20 l=2
+  ad=0.2n pd=60u as=59.999996p ps=46u
M3596 AOI22X1_28/a_11_6# HAX1_16/YS gnd Gnd nfet w=20 l=2
+  ad=0 pd=0 as=0 ps=0
M3597 AOI22X1_28/a_2_54# AND2X2_8/Y vdd vdd pfet w=40 l=2
+  ad=0.64n pd=0.272m as=0 ps=0
M3598 AOI22X1_28/a_28_6# invader_2_coord_x[2] NAND2X1_36/A Gnd nfet w=20 l=2
+  ad=0 pd=0 as=0 ps=0
M3599 vdd HAX1_16/YS AOI22X1_28/a_2_54# vdd pfet w=40 l=2
+  ad=0 pd=0 as=0 ps=0
M3600 NAND2X1_36/A invader_2_coord_x[2] AOI22X1_28/a_2_54# vdd pfet w=40 l=2
+  ad=0.24n pd=92u as=0 ps=0
M3601 AOI22X1_28/a_2_54# NOR2X1_29/B NAND2X1_36/A vdd pfet w=40 l=2
+  ad=0 pd=0 as=0 ps=0
M3602 gnd HAX1_16/YS OAI21X1_1/a_2_6# Gnd nfet w=20 l=2
+  ad=0 pd=0 as=0.22n ps=0.102m
M3603 vdd OAI21X1_1/C OAI21X1_1/Y vdd pfet w=20 l=2
+  ad=0 pd=0 as=0.22n ps=92u
M3604 OAI21X1_1/Y OAI21X1_1/C OAI21X1_1/a_2_6# Gnd nfet w=20 l=2
+  ad=100p pd=50u as=0 ps=0
M3605 OAI21X1_1/Y INVX2_19/Y OAI21X1_1/a_9_54# vdd pfet w=40 l=2
+  ad=0 pd=0 as=0.12n ps=86u
M3606 OAI21X1_1/a_9_54# HAX1_16/YS vdd vdd pfet w=40 l=2
+  ad=0 pd=0 as=0 ps=0
M3607 OAI21X1_1/a_2_6# INVX2_19/Y gnd Gnd nfet w=20 l=2
+  ad=0 pd=0 as=0 ps=0
M3608 gnd shield_coord_x[1] XOR2X1_4/a_2_6# Gnd nfet w=20 l=2
+  ad=0 pd=0 as=100p ps=50u
M3609 XOR2X1_4/Y XOR2X1_4/a_2_6# XOR2X1_4/a_18_6# Gnd nfet w=20 l=2
+  ad=0.2n pd=60u as=59.999996p ps=46u
M3610 XOR2X1_4/a_13_43# shield_coord_x[2] gnd Gnd nfet w=20 l=2
+  ad=100p pd=50u as=0 ps=0
M3611 XOR2X1_4/a_18_54# XOR2X1_4/a_13_43# vdd vdd pfet w=40 l=2
+  ad=0.12n pd=86u as=0 ps=0
M3612 XOR2X1_4/a_35_6# shield_coord_x[1] XOR2X1_4/Y Gnd nfet w=20 l=2
+  ad=59.999996p pd=46u as=0 ps=0
M3613 XOR2X1_4/a_18_6# XOR2X1_4/a_13_43# gnd Gnd nfet w=20 l=2
+  ad=0 pd=0 as=0 ps=0
M3614 vdd shield_coord_x[1] XOR2X1_4/a_2_6# vdd pfet w=40 l=2
+  ad=0 pd=0 as=0.2n ps=90u
M3615 vdd shield_coord_x[2] XOR2X1_4/a_35_54# vdd pfet w=40 l=2
+  ad=0 pd=0 as=0.12n ps=86u
M3616 XOR2X1_4/Y shield_coord_x[1] XOR2X1_4/a_18_54# vdd pfet w=40 l=2
+  ad=0.4n pd=100u as=0 ps=0
M3617 XOR2X1_4/a_35_54# XOR2X1_4/a_2_6# XOR2X1_4/Y vdd pfet w=40 l=2
+  ad=0 pd=0 as=0 ps=0
M3618 XOR2X1_4/a_13_43# shield_coord_x[2] vdd vdd pfet w=40 l=2
+  ad=0.2n pd=90u as=0 ps=0
M3619 gnd shield_coord_x[2] XOR2X1_4/a_35_6# Gnd nfet w=20 l=2
+  ad=0 pd=0 as=0 ps=0
M3620 INVX2_122/Y INVX2_122/A gnd Gnd nfet w=20 l=2
+  ad=100p pd=50u as=0 ps=0
M3621 INVX2_122/Y INVX2_122/A vdd vdd pfet w=40 l=2
+  ad=0.2n pd=90u as=0 ps=0
M3622 INVX2_111/Y OAI22X1_9/B gnd Gnd nfet w=20 l=2
+  ad=100p pd=50u as=0 ps=0
M3623 INVX2_111/Y OAI22X1_9/B vdd vdd pfet w=40 l=2
+  ad=0.2n pd=90u as=0 ps=0
M3624 XOR2X1_17/A INVX2_100/A gnd Gnd nfet w=20 l=2
+  ad=100p pd=50u as=0 ps=0
M3625 XOR2X1_17/A INVX2_100/A vdd vdd pfet w=40 l=2
+  ad=0.2n pd=90u as=0 ps=0
M3626 INVX2_133/Y OR2X1_11/A gnd Gnd nfet w=20 l=2
+  ad=100p pd=50u as=0 ps=0
M3627 INVX2_133/Y OR2X1_11/A vdd vdd pfet w=40 l=2
+  ad=0.2n pd=90u as=0 ps=0
M3628 INVX2_166/Y INVX2_166/A gnd Gnd nfet w=20 l=2
+  ad=100p pd=50u as=0 ps=0
M3629 INVX2_166/Y INVX2_166/A vdd vdd pfet w=40 l=2
+  ad=0.2n pd=90u as=0 ps=0
M3630 INVX2_144/Y INVX2_144/A gnd Gnd nfet w=20 l=2
+  ad=100p pd=50u as=0 ps=0
M3631 INVX2_144/Y INVX2_144/A vdd vdd pfet w=40 l=2
+  ad=0.2n pd=90u as=0 ps=0
M3632 INVX2_155/Y INVX2_155/A gnd Gnd nfet w=20 l=2
+  ad=100p pd=50u as=0 ps=0
M3633 INVX2_155/Y INVX2_155/A vdd vdd pfet w=40 l=2
+  ad=0.2n pd=90u as=0 ps=0
M3634 OAI21X1_4/B player_bullet_coord_x[1] gnd Gnd nfet w=20 l=2
+  ad=100p pd=50u as=0 ps=0
M3635 OAI21X1_4/B player_bullet_coord_x[1] vdd vdd pfet w=40 l=2
+  ad=0.2n pd=90u as=0 ps=0
M3636 DFFNEGX1_17/a_76_6# BUFX2_6/Y DFFNEGX1_17/a_66_6# Gnd nfet w=10 l=2
+  ad=29.999998p pd=26u as=80p ps=36u
M3637 gnd BUFX2_6/Y DFFNEGX1_17/a_2_6# Gnd nfet w=20 l=2
+  ad=0 pd=0 as=100p ps=50u
M3638 DFFNEGX1_17/a_66_6# DFFNEGX1_17/a_2_6# DFFNEGX1_17/a_61_6# Gnd nfet w=10 l=2
+  ad=0 pd=0 as=29.999998p ps=26u
M3639 player_bullet_coord_x[2] DFFNEGX1_17/a_66_6# gnd Gnd nfet w=20 l=2
+  ad=100p pd=50u as=0 ps=0
M3640 DFFNEGX1_17/a_23_6# BUFX2_6/Y DFFNEGX1_17/a_17_6# Gnd nfet w=10 l=2
+  ad=59.999996p pd=32u as=40p ps=28u
M3641 DFFNEGX1_17/a_23_6# DFFNEGX1_17/a_2_6# DFFNEGX1_17/a_17_74# vdd pfet w=20 l=2
+  ad=0.12n pd=52u as=80p ps=48u
M3642 gnd DFFNEGX1_17/a_34_4# DFFNEGX1_17/a_31_6# Gnd nfet w=10 l=2
+  ad=0 pd=0 as=29.999998p ps=26u
M3643 vdd DFFNEGX1_17/a_34_4# DFFNEGX1_17/a_31_74# vdd pfet w=20 l=2
+  ad=0 pd=0 as=80p ps=48u
M3644 DFFNEGX1_17/a_61_74# DFFNEGX1_17/a_34_4# vdd vdd pfet w=20 l=2
+  ad=59.999996p pd=46u as=0 ps=0
M3645 DFFNEGX1_17/a_34_4# DFFNEGX1_17/a_23_6# vdd vdd pfet w=20 l=2
+  ad=100p pd=50u as=0 ps=0
M3646 DFFNEGX1_17/a_34_4# DFFNEGX1_17/a_23_6# gnd Gnd nfet w=10 l=2
+  ad=50p pd=30u as=0 ps=0
M3647 vdd player_bullet_coord_x[2] DFFNEGX1_17/a_76_84# vdd pfet w=10 l=2
+  ad=0 pd=0 as=29.999998p ps=26u
M3648 gnd player_bullet_coord_x[2] DFFNEGX1_17/a_76_6# Gnd nfet w=10 l=2
+  ad=0 pd=0 as=0 ps=0
M3649 DFFNEGX1_17/a_61_6# DFFNEGX1_17/a_34_4# gnd Gnd nfet w=10 l=2
+  ad=0 pd=0 as=0 ps=0
M3650 DFFNEGX1_17/a_76_84# DFFNEGX1_17/a_2_6# DFFNEGX1_17/a_66_6# vdd pfet w=10 l=2
+  ad=0 pd=0 as=0.15n ps=56u
M3651 player_bullet_coord_x[2] DFFNEGX1_17/a_66_6# vdd vdd pfet w=40 l=2
+  ad=0.2n pd=90u as=0 ps=0
M3652 vdd BUFX2_6/Y DFFNEGX1_17/a_2_6# vdd pfet w=40 l=2
+  ad=0 pd=0 as=0.2n ps=90u
M3653 DFFNEGX1_17/a_31_6# DFFNEGX1_17/a_2_6# DFFNEGX1_17/a_23_6# Gnd nfet w=10 l=2
+  ad=0 pd=0 as=0 ps=0
M3654 DFFNEGX1_17/a_66_6# BUFX2_6/Y DFFNEGX1_17/a_61_74# vdd pfet w=20 l=2
+  ad=0 pd=0 as=0 ps=0
M3655 DFFNEGX1_17/a_17_74# INVX2_142/Y vdd vdd pfet w=20 l=2
+  ad=0 pd=0 as=0 ps=0
M3656 DFFNEGX1_17/a_31_74# BUFX2_6/Y DFFNEGX1_17/a_23_6# vdd pfet w=20 l=2
+  ad=0 pd=0 as=0 ps=0
M3657 DFFNEGX1_17/a_17_6# INVX2_142/Y gnd Gnd nfet w=10 l=2
+  ad=0 pd=0 as=0 ps=0
M3658 DFFNEGX1_28/a_76_6# BUFX2_6/Y DFFNEGX1_28/a_66_6# Gnd nfet w=10 l=2
+  ad=29.999998p pd=26u as=80p ps=36u
M3659 gnd BUFX2_6/Y DFFNEGX1_28/a_2_6# Gnd nfet w=20 l=2
+  ad=0 pd=0 as=100p ps=50u
M3660 DFFNEGX1_28/a_66_6# DFFNEGX1_28/a_2_6# DFFNEGX1_28/a_61_6# Gnd nfet w=10 l=2
+  ad=0 pd=0 as=29.999998p ps=26u
M3661 invader_2_coord_y[1] DFFNEGX1_28/a_66_6# gnd Gnd nfet w=20 l=2
+  ad=100p pd=50u as=0 ps=0
M3662 DFFNEGX1_28/a_23_6# BUFX2_6/Y DFFNEGX1_28/a_17_6# Gnd nfet w=10 l=2
+  ad=59.999996p pd=32u as=40p ps=28u
M3663 DFFNEGX1_28/a_23_6# DFFNEGX1_28/a_2_6# DFFNEGX1_28/a_17_74# vdd pfet w=20 l=2
+  ad=0.12n pd=52u as=80p ps=48u
M3664 gnd DFFNEGX1_28/a_34_4# DFFNEGX1_28/a_31_6# Gnd nfet w=10 l=2
+  ad=0 pd=0 as=29.999998p ps=26u
M3665 vdd DFFNEGX1_28/a_34_4# DFFNEGX1_28/a_31_74# vdd pfet w=20 l=2
+  ad=0 pd=0 as=80p ps=48u
M3666 DFFNEGX1_28/a_61_74# DFFNEGX1_28/a_34_4# vdd vdd pfet w=20 l=2
+  ad=59.999996p pd=46u as=0 ps=0
M3667 DFFNEGX1_28/a_34_4# DFFNEGX1_28/a_23_6# vdd vdd pfet w=20 l=2
+  ad=100p pd=50u as=0 ps=0
M3668 DFFNEGX1_28/a_34_4# DFFNEGX1_28/a_23_6# gnd Gnd nfet w=10 l=2
+  ad=50p pd=30u as=0 ps=0
M3669 vdd invader_2_coord_y[1] DFFNEGX1_28/a_76_84# vdd pfet w=10 l=2
+  ad=0 pd=0 as=29.999998p ps=26u
M3670 gnd invader_2_coord_y[1] DFFNEGX1_28/a_76_6# Gnd nfet w=10 l=2
+  ad=0 pd=0 as=0 ps=0
M3671 DFFNEGX1_28/a_61_6# DFFNEGX1_28/a_34_4# gnd Gnd nfet w=10 l=2
+  ad=0 pd=0 as=0 ps=0
M3672 DFFNEGX1_28/a_76_84# DFFNEGX1_28/a_2_6# DFFNEGX1_28/a_66_6# vdd pfet w=10 l=2
+  ad=0 pd=0 as=0.15n ps=56u
M3673 invader_2_coord_y[1] DFFNEGX1_28/a_66_6# vdd vdd pfet w=40 l=2
+  ad=0.2n pd=90u as=0 ps=0
M3674 vdd BUFX2_6/Y DFFNEGX1_28/a_2_6# vdd pfet w=40 l=2
+  ad=0 pd=0 as=0.2n ps=90u
M3675 DFFNEGX1_28/a_31_6# DFFNEGX1_28/a_2_6# DFFNEGX1_28/a_23_6# Gnd nfet w=10 l=2
+  ad=0 pd=0 as=0 ps=0
M3676 DFFNEGX1_28/a_66_6# BUFX2_6/Y DFFNEGX1_28/a_61_74# vdd pfet w=20 l=2
+  ad=0 pd=0 as=0 ps=0
M3677 DFFNEGX1_28/a_17_74# OAI21X1_63/Y vdd vdd pfet w=20 l=2
+  ad=0 pd=0 as=0 ps=0
M3678 DFFNEGX1_28/a_31_74# BUFX2_6/Y DFFNEGX1_28/a_23_6# vdd pfet w=20 l=2
+  ad=0 pd=0 as=0 ps=0
M3679 DFFNEGX1_28/a_17_6# OAI21X1_63/Y gnd Gnd nfet w=10 l=2
+  ad=0 pd=0 as=0 ps=0
M3680 DFFNEGX1_39/a_76_6# clka DFFNEGX1_39/a_66_6# Gnd nfet w=10 l=2
+  ad=29.999998p pd=26u as=80p ps=36u
M3681 gnd clka DFFNEGX1_39/a_2_6# Gnd nfet w=20 l=2
+  ad=0 pd=0 as=100p ps=50u
M3682 DFFNEGX1_39/a_66_6# DFFNEGX1_39/a_2_6# DFFNEGX1_39/a_61_6# Gnd nfet w=10 l=2
+  ad=0 pd=0 as=29.999998p ps=26u
M3683 INVX2_56/A DFFNEGX1_39/a_66_6# gnd Gnd nfet w=20 l=2
+  ad=100p pd=50u as=0 ps=0
M3684 DFFNEGX1_39/a_23_6# clka DFFNEGX1_39/a_17_6# Gnd nfet w=10 l=2
+  ad=59.999996p pd=32u as=40p ps=28u
M3685 DFFNEGX1_39/a_23_6# DFFNEGX1_39/a_2_6# DFFNEGX1_39/a_17_74# vdd pfet w=20 l=2
+  ad=0.12n pd=52u as=80p ps=48u
M3686 gnd DFFNEGX1_39/a_34_4# DFFNEGX1_39/a_31_6# Gnd nfet w=10 l=2
+  ad=0 pd=0 as=29.999998p ps=26u
M3687 vdd DFFNEGX1_39/a_34_4# DFFNEGX1_39/a_31_74# vdd pfet w=20 l=2
+  ad=0 pd=0 as=80p ps=48u
M3688 DFFNEGX1_39/a_61_74# DFFNEGX1_39/a_34_4# vdd vdd pfet w=20 l=2
+  ad=59.999996p pd=46u as=0 ps=0
M3689 DFFNEGX1_39/a_34_4# DFFNEGX1_39/a_23_6# vdd vdd pfet w=20 l=2
+  ad=100p pd=50u as=0 ps=0
M3690 DFFNEGX1_39/a_34_4# DFFNEGX1_39/a_23_6# gnd Gnd nfet w=10 l=2
+  ad=50p pd=30u as=0 ps=0
M3691 vdd INVX2_56/A DFFNEGX1_39/a_76_84# vdd pfet w=10 l=2
+  ad=0 pd=0 as=29.999998p ps=26u
M3692 gnd INVX2_56/A DFFNEGX1_39/a_76_6# Gnd nfet w=10 l=2
+  ad=0 pd=0 as=0 ps=0
M3693 DFFNEGX1_39/a_61_6# DFFNEGX1_39/a_34_4# gnd Gnd nfet w=10 l=2
+  ad=0 pd=0 as=0 ps=0
M3694 DFFNEGX1_39/a_76_84# DFFNEGX1_39/a_2_6# DFFNEGX1_39/a_66_6# vdd pfet w=10 l=2
+  ad=0 pd=0 as=0.15n ps=56u
M3695 INVX2_56/A DFFNEGX1_39/a_66_6# vdd vdd pfet w=40 l=2
+  ad=0.2n pd=90u as=0 ps=0
M3696 vdd clka DFFNEGX1_39/a_2_6# vdd pfet w=40 l=2
+  ad=0 pd=0 as=0.2n ps=90u
M3697 DFFNEGX1_39/a_31_6# DFFNEGX1_39/a_2_6# DFFNEGX1_39/a_23_6# Gnd nfet w=10 l=2
+  ad=0 pd=0 as=0 ps=0
M3698 DFFNEGX1_39/a_66_6# clka DFFNEGX1_39/a_61_74# vdd pfet w=20 l=2
+  ad=0 pd=0 as=0 ps=0
M3699 DFFNEGX1_39/a_17_74# OAI21X1_91/Y vdd vdd pfet w=20 l=2
+  ad=0 pd=0 as=0 ps=0
M3700 DFFNEGX1_39/a_31_74# clka DFFNEGX1_39/a_23_6# vdd pfet w=20 l=2
+  ad=0 pd=0 as=0 ps=0
M3701 DFFNEGX1_39/a_17_6# OAI21X1_91/Y gnd Gnd nfet w=10 l=2
+  ad=0 pd=0 as=0 ps=0
M3702 gnd invader_2_coord_x[1] XOR2X1_15/a_2_6# Gnd nfet w=20 l=2
+  ad=0 pd=0 as=100p ps=50u
M3703 XOR2X1_15/Y XOR2X1_15/a_2_6# XOR2X1_15/a_18_6# Gnd nfet w=20 l=2
+  ad=0.2n pd=60u as=59.999996p ps=46u
M3704 XOR2X1_15/a_13_43# player_coord_x[1] gnd Gnd nfet w=20 l=2
+  ad=100p pd=50u as=0 ps=0
M3705 XOR2X1_15/a_18_54# XOR2X1_15/a_13_43# vdd vdd pfet w=40 l=2
+  ad=0.12n pd=86u as=0 ps=0
M3706 XOR2X1_15/a_35_6# invader_2_coord_x[1] XOR2X1_15/Y Gnd nfet w=20 l=2
+  ad=59.999996p pd=46u as=0 ps=0
M3707 XOR2X1_15/a_18_6# XOR2X1_15/a_13_43# gnd Gnd nfet w=20 l=2
+  ad=0 pd=0 as=0 ps=0
M3708 vdd invader_2_coord_x[1] XOR2X1_15/a_2_6# vdd pfet w=40 l=2
+  ad=0 pd=0 as=0.2n ps=90u
M3709 vdd player_coord_x[1] XOR2X1_15/a_35_54# vdd pfet w=40 l=2
+  ad=0 pd=0 as=0.12n ps=86u
M3710 XOR2X1_15/Y invader_2_coord_x[1] XOR2X1_15/a_18_54# vdd pfet w=40 l=2
+  ad=0.4n pd=100u as=0 ps=0
M3711 XOR2X1_15/a_35_54# XOR2X1_15/a_2_6# XOR2X1_15/Y vdd pfet w=40 l=2
+  ad=0 pd=0 as=0 ps=0
M3712 XOR2X1_15/a_13_43# player_coord_x[1] vdd vdd pfet w=40 l=2
+  ad=0.2n pd=90u as=0 ps=0
M3713 gnd player_coord_x[1] XOR2X1_15/a_35_6# Gnd nfet w=20 l=2
+  ad=0 pd=0 as=0 ps=0
M3714 NAND3X1_5/Y NAND3X1_5/A vdd vdd pfet w=20 l=2
+  ad=0.22n pd=0.102m as=0 ps=0
M3715 NAND3X1_5/a_9_6# NAND3X1_5/A gnd Gnd nfet w=30 l=2
+  ad=90p pd=66u as=0 ps=0
M3716 NAND3X1_5/Y HAX1_10/YS vdd vdd pfet w=20 l=2
+  ad=0 pd=0 as=0 ps=0
M3717 NAND3X1_5/Y HAX1_10/YS NAND3X1_5/a_14_6# Gnd nfet w=30 l=2
+  ad=0.15n pd=70u as=90p ps=66u
M3718 vdd INVX2_19/Y NAND3X1_5/Y vdd pfet w=20 l=2
+  ad=0 pd=0 as=0 ps=0
M3719 NAND3X1_5/a_14_6# INVX2_19/Y NAND3X1_5/a_9_6# Gnd nfet w=30 l=2
+  ad=0 pd=0 as=0 ps=0
M3720 gnd player_coord_x[1] OAI21X1_112/a_2_6# Gnd nfet w=20 l=2
+  ad=0 pd=0 as=0.22n ps=0.102m
M3721 vdd player_coord_x[2] OAI21X1_112/Y vdd pfet w=20 l=2
+  ad=0 pd=0 as=0.22n ps=92u
M3722 OAI21X1_112/Y player_coord_x[2] OAI21X1_112/a_2_6# Gnd nfet w=20 l=2
+  ad=100p pd=50u as=0 ps=0
M3723 OAI21X1_112/Y player_coord_x[0] OAI21X1_112/a_9_54# vdd pfet w=40 l=2
+  ad=0 pd=0 as=0.12n ps=86u
M3724 OAI21X1_112/a_9_54# player_coord_x[1] vdd vdd pfet w=40 l=2
+  ad=0 pd=0 as=0 ps=0
M3725 OAI21X1_112/a_2_6# player_coord_x[0] gnd Gnd nfet w=20 l=2
+  ad=0 pd=0 as=0 ps=0
M3726 gnd INVX2_88/A OAI21X1_101/a_2_6# Gnd nfet w=20 l=2
+  ad=0 pd=0 as=0.22n ps=0.102m
M3727 vdd NAND2X1_1/B OR2X1_11/A vdd pfet w=20 l=2
+  ad=0 pd=0 as=0.22n ps=92u
M3728 OR2X1_11/A NAND2X1_1/B OAI21X1_101/a_2_6# Gnd nfet w=20 l=2
+  ad=100p pd=50u as=0 ps=0
M3729 OR2X1_11/A AND2X2_18/B OAI21X1_101/a_9_54# vdd pfet w=40 l=2
+  ad=0 pd=0 as=0.12n ps=86u
M3730 OAI21X1_101/a_9_54# INVX2_88/A vdd vdd pfet w=40 l=2
+  ad=0 pd=0 as=0 ps=0
M3731 OAI21X1_101/a_2_6# AND2X2_18/B gnd Gnd nfet w=20 l=2
+  ad=0 pd=0 as=0 ps=0
M3732 gnd reset OAI21X1_123/a_2_6# Gnd nfet w=20 l=2
+  ad=0 pd=0 as=0.22n ps=0.102m
M3733 vdd NAND2X1_62/Y OAI21X1_123/Y vdd pfet w=20 l=2
+  ad=0 pd=0 as=0.22n ps=92u
M3734 OAI21X1_123/Y NAND2X1_62/Y OAI21X1_123/a_2_6# Gnd nfet w=20 l=2
+  ad=100p pd=50u as=0 ps=0
M3735 OAI21X1_123/Y INVX2_127/A OAI21X1_123/a_9_54# vdd pfet w=40 l=2
+  ad=0 pd=0 as=0.12n ps=86u
M3736 OAI21X1_123/a_9_54# reset vdd vdd pfet w=40 l=2
+  ad=0 pd=0 as=0 ps=0
M3737 OAI21X1_123/a_2_6# INVX2_127/A gnd Gnd nfet w=20 l=2
+  ad=0 pd=0 as=0 ps=0
M3738 gnd invader_2_coord_x[1] OAI21X1_145/a_2_6# Gnd nfet w=20 l=2
+  ad=0 pd=0 as=0.22n ps=0.102m
M3739 vdd OR2X1_17/A OAI21X1_145/Y vdd pfet w=20 l=2
+  ad=0 pd=0 as=0.22n ps=92u
M3740 OAI21X1_145/Y OR2X1_17/A OAI21X1_145/a_2_6# Gnd nfet w=20 l=2
+  ad=100p pd=50u as=0 ps=0
M3741 OAI21X1_145/Y INVX2_99/A OAI21X1_145/a_9_54# vdd pfet w=40 l=2
+  ad=0 pd=0 as=0.12n ps=86u
M3742 OAI21X1_145/a_9_54# invader_2_coord_x[1] vdd vdd pfet w=40 l=2
+  ad=0 pd=0 as=0 ps=0
M3743 OAI21X1_145/a_2_6# INVX2_99/A gnd Gnd nfet w=20 l=2
+  ad=0 pd=0 as=0 ps=0
M3744 gnd INVX2_112/Y OAI21X1_134/a_2_6# Gnd nfet w=20 l=2
+  ad=0 pd=0 as=0.22n ps=0.102m
M3745 vdd OAI21X1_135/Y OAI21X1_134/Y vdd pfet w=20 l=2
+  ad=0 pd=0 as=0.22n ps=92u
M3746 OAI21X1_134/Y OAI21X1_135/Y OAI21X1_134/a_2_6# Gnd nfet w=20 l=2
+  ad=100p pd=50u as=0 ps=0
M3747 OAI21X1_134/Y INVX2_108/A OAI21X1_134/a_9_54# vdd pfet w=40 l=2
+  ad=0 pd=0 as=0.12n ps=86u
M3748 OAI21X1_134/a_9_54# INVX2_112/Y vdd vdd pfet w=40 l=2
+  ad=0 pd=0 as=0 ps=0
M3749 OAI21X1_134/a_2_6# INVX2_108/A gnd Gnd nfet w=20 l=2
+  ad=0 pd=0 as=0 ps=0
M3750 gnd INVX2_116/Y AOI22X1_18/a_28_6# Gnd nfet w=20 l=2
+  ad=0 pd=0 as=59.999996p ps=46u
M3751 NAND2X1_0/A INVX2_2/A AOI22X1_18/a_11_6# Gnd nfet w=20 l=2
+  ad=0.2n pd=60u as=59.999996p ps=46u
M3752 AOI22X1_18/a_11_6# NOR2X1_22/Y gnd Gnd nfet w=20 l=2
+  ad=0 pd=0 as=0 ps=0
M3753 AOI22X1_18/a_2_54# INVX2_2/A vdd vdd pfet w=40 l=2
+  ad=0.64n pd=0.272m as=0 ps=0
M3754 AOI22X1_18/a_28_6# INVX2_2/Y NAND2X1_0/A Gnd nfet w=20 l=2
+  ad=0 pd=0 as=0 ps=0
M3755 vdd NOR2X1_22/Y AOI22X1_18/a_2_54# vdd pfet w=40 l=2
+  ad=0 pd=0 as=0 ps=0
M3756 NAND2X1_0/A INVX2_2/Y AOI22X1_18/a_2_54# vdd pfet w=40 l=2
+  ad=0.24n pd=92u as=0 ps=0
M3757 AOI22X1_18/a_2_54# INVX2_116/Y NAND2X1_0/A vdd pfet w=40 l=2
+  ad=0 pd=0 as=0 ps=0
M3758 gnd INVX2_45/A AOI22X1_29/a_28_6# Gnd nfet w=20 l=2
+  ad=0 pd=0 as=59.999996p ps=46u
M3759 OAI21X1_60/C AND2X2_9/Y AOI22X1_29/a_11_6# Gnd nfet w=20 l=2
+  ad=0.2n pd=60u as=59.999996p ps=46u
M3760 AOI22X1_29/a_11_6# INVX2_47/Y gnd Gnd nfet w=20 l=2
+  ad=0 pd=0 as=0 ps=0
M3761 AOI22X1_29/a_2_54# AND2X2_9/Y vdd vdd pfet w=40 l=2
+  ad=0.64n pd=0.272m as=0 ps=0
M3762 AOI22X1_29/a_28_6# AND2X2_8/Y OAI21X1_60/C Gnd nfet w=20 l=2
+  ad=0 pd=0 as=0 ps=0
M3763 vdd INVX2_47/Y AOI22X1_29/a_2_54# vdd pfet w=40 l=2
+  ad=0 pd=0 as=0 ps=0
M3764 OAI21X1_60/C AND2X2_8/Y AOI22X1_29/a_2_54# vdd pfet w=40 l=2
+  ad=0.24n pd=92u as=0 ps=0
M3765 AOI22X1_29/a_2_54# INVX2_45/A OAI21X1_60/C vdd pfet w=40 l=2
+  ad=0 pd=0 as=0 ps=0
M3766 vdd invader_1_coord_x[2] HAX1_10/a_2_74# vdd pfet w=20 l=2
+  ad=0 pd=0 as=0.2n ps=100u
M3767 HAX1_10/a_41_74# HAX1_10/a_2_74# vdd vdd pfet w=20 l=2
+  ad=0.22n pd=92u as=0 ps=0
M3768 HAX1_10/a_9_6# invader_1_coord_x[2] gnd Gnd nfet w=20 l=2
+  ad=59.999996p pd=46u as=0 ps=0
M3769 HAX1_10/a_41_74# HAX1_10/B HAX1_10/a_38_6# Gnd nfet w=20 l=2
+  ad=0.12n pd=52u as=0.216n ps=0.102m
M3770 vdd invader_1_coord_x[2] HAX1_10/a_49_54# vdd pfet w=40 l=2
+  ad=0 pd=0 as=0.12n ps=86u
M3771 vdd HAX1_10/a_2_74# HAX1_9/B vdd pfet w=20 l=2
+  ad=0 pd=0 as=100p ps=50u
M3772 HAX1_10/a_38_6# HAX1_10/a_2_74# gnd Gnd nfet w=20 l=2
+  ad=0 pd=0 as=0 ps=0
M3773 HAX1_10/YS HAX1_10/a_41_74# vdd vdd pfet w=20 l=2
+  ad=100p pd=50u as=0 ps=0
M3774 HAX1_10/a_38_6# invader_1_coord_x[2] HAX1_10/a_41_74# Gnd nfet w=20 l=2
+  ad=0 pd=0 as=0 ps=0
M3775 HAX1_10/YS HAX1_10/a_41_74# gnd Gnd nfet w=10 l=2
+  ad=50p pd=30u as=0 ps=0
M3776 HAX1_10/a_2_74# HAX1_10/B vdd vdd pfet w=20 l=2
+  ad=0 pd=0 as=0 ps=0
M3777 HAX1_10/a_2_74# HAX1_10/B HAX1_10/a_9_6# Gnd nfet w=20 l=2
+  ad=100p pd=50u as=0 ps=0
M3778 HAX1_10/a_49_54# HAX1_10/B HAX1_10/a_41_74# vdd pfet w=40 l=2
+  ad=0 pd=0 as=0 ps=0
M3779 gnd HAX1_10/a_2_74# HAX1_9/B Gnd nfet w=10 l=2
+  ad=0 pd=0 as=50p ps=30u
M3780 gnd player_bullet_coord_x[3] OAI21X1_2/a_2_6# Gnd nfet w=20 l=2
+  ad=0 pd=0 as=0.22n ps=0.102m
M3781 vdd OAI21X1_2/C INVX2_49/A vdd pfet w=20 l=2
+  ad=0 pd=0 as=0.22n ps=92u
M3782 INVX2_49/A OAI21X1_2/C OAI21X1_2/a_2_6# Gnd nfet w=20 l=2
+  ad=100p pd=50u as=0 ps=0
M3783 INVX2_49/A INVX2_48/Y OAI21X1_2/a_9_54# vdd pfet w=40 l=2
+  ad=0 pd=0 as=0.12n ps=86u
M3784 OAI21X1_2/a_9_54# player_bullet_coord_x[3] vdd vdd pfet w=40 l=2
+  ad=0 pd=0 as=0 ps=0
M3785 OAI21X1_2/a_2_6# INVX2_48/Y gnd Gnd nfet w=20 l=2
+  ad=0 pd=0 as=0 ps=0
M3786 DFFNEGX1_0/a_76_6# BUFX2_7/Y DFFNEGX1_0/a_66_6# Gnd nfet w=10 l=2
+  ad=29.999998p pd=26u as=80p ps=36u
M3787 gnd BUFX2_7/Y DFFNEGX1_0/a_2_6# Gnd nfet w=20 l=2
+  ad=0 pd=0 as=100p ps=50u
M3788 DFFNEGX1_0/a_66_6# DFFNEGX1_0/a_2_6# DFFNEGX1_0/a_61_6# Gnd nfet w=10 l=2
+  ad=0 pd=0 as=29.999998p ps=26u
M3789 invader_bullet_coord_y[0] DFFNEGX1_0/a_66_6# gnd Gnd nfet w=20 l=2
+  ad=100p pd=50u as=0 ps=0
M3790 DFFNEGX1_0/a_23_6# BUFX2_7/Y DFFNEGX1_0/a_17_6# Gnd nfet w=10 l=2
+  ad=59.999996p pd=32u as=40p ps=28u
M3791 DFFNEGX1_0/a_23_6# DFFNEGX1_0/a_2_6# DFFNEGX1_0/a_17_74# vdd pfet w=20 l=2
+  ad=0.12n pd=52u as=80p ps=48u
M3792 gnd DFFNEGX1_0/a_34_4# DFFNEGX1_0/a_31_6# Gnd nfet w=10 l=2
+  ad=0 pd=0 as=29.999998p ps=26u
M3793 vdd DFFNEGX1_0/a_34_4# DFFNEGX1_0/a_31_74# vdd pfet w=20 l=2
+  ad=0 pd=0 as=80p ps=48u
M3794 DFFNEGX1_0/a_61_74# DFFNEGX1_0/a_34_4# vdd vdd pfet w=20 l=2
+  ad=59.999996p pd=46u as=0 ps=0
M3795 DFFNEGX1_0/a_34_4# DFFNEGX1_0/a_23_6# vdd vdd pfet w=20 l=2
+  ad=100p pd=50u as=0 ps=0
M3796 DFFNEGX1_0/a_34_4# DFFNEGX1_0/a_23_6# gnd Gnd nfet w=10 l=2
+  ad=50p pd=30u as=0 ps=0
M3797 vdd invader_bullet_coord_y[0] DFFNEGX1_0/a_76_84# vdd pfet w=10 l=2
+  ad=0 pd=0 as=29.999998p ps=26u
M3798 gnd invader_bullet_coord_y[0] DFFNEGX1_0/a_76_6# Gnd nfet w=10 l=2
+  ad=0 pd=0 as=0 ps=0
M3799 DFFNEGX1_0/a_61_6# DFFNEGX1_0/a_34_4# gnd Gnd nfet w=10 l=2
+  ad=0 pd=0 as=0 ps=0
M3800 DFFNEGX1_0/a_76_84# DFFNEGX1_0/a_2_6# DFFNEGX1_0/a_66_6# vdd pfet w=10 l=2
+  ad=0 pd=0 as=0.15n ps=56u
M3801 invader_bullet_coord_y[0] DFFNEGX1_0/a_66_6# vdd vdd pfet w=40 l=2
+  ad=0.2n pd=90u as=0 ps=0
M3802 vdd BUFX2_7/Y DFFNEGX1_0/a_2_6# vdd pfet w=40 l=2
+  ad=0 pd=0 as=0.2n ps=90u
M3803 DFFNEGX1_0/a_31_6# DFFNEGX1_0/a_2_6# DFFNEGX1_0/a_23_6# Gnd nfet w=10 l=2
+  ad=0 pd=0 as=0 ps=0
M3804 DFFNEGX1_0/a_66_6# BUFX2_7/Y DFFNEGX1_0/a_61_74# vdd pfet w=20 l=2
+  ad=0 pd=0 as=0 ps=0
M3805 DFFNEGX1_0/a_17_74# OAI21X1_46/Y vdd vdd pfet w=20 l=2
+  ad=0 pd=0 as=0 ps=0
M3806 DFFNEGX1_0/a_31_74# BUFX2_7/Y DFFNEGX1_0/a_23_6# vdd pfet w=20 l=2
+  ad=0 pd=0 as=0 ps=0
M3807 DFFNEGX1_0/a_17_6# OAI21X1_46/Y gnd Gnd nfet w=10 l=2
+  ad=0 pd=0 as=0 ps=0
M3808 gnd XOR2X1_5/A XOR2X1_5/a_2_6# Gnd nfet w=20 l=2
+  ad=0 pd=0 as=100p ps=50u
M3809 XOR2X1_5/Y XOR2X1_5/a_2_6# XOR2X1_5/a_18_6# Gnd nfet w=20 l=2
+  ad=0.2n pd=60u as=59.999996p ps=46u
M3810 XOR2X1_5/a_13_43# invader_1_coord_x[3] gnd Gnd nfet w=20 l=2
+  ad=100p pd=50u as=0 ps=0
M3811 XOR2X1_5/a_18_54# XOR2X1_5/a_13_43# vdd vdd pfet w=40 l=2
+  ad=0.12n pd=86u as=0 ps=0
M3812 XOR2X1_5/a_35_6# XOR2X1_5/A XOR2X1_5/Y Gnd nfet w=20 l=2
+  ad=59.999996p pd=46u as=0 ps=0
M3813 XOR2X1_5/a_18_6# XOR2X1_5/a_13_43# gnd Gnd nfet w=20 l=2
+  ad=0 pd=0 as=0 ps=0
M3814 vdd XOR2X1_5/A XOR2X1_5/a_2_6# vdd pfet w=40 l=2
+  ad=0 pd=0 as=0.2n ps=90u
M3815 vdd invader_1_coord_x[3] XOR2X1_5/a_35_54# vdd pfet w=40 l=2
+  ad=0 pd=0 as=0.12n ps=86u
M3816 XOR2X1_5/Y XOR2X1_5/A XOR2X1_5/a_18_54# vdd pfet w=40 l=2
+  ad=0.4n pd=100u as=0 ps=0
M3817 XOR2X1_5/a_35_54# XOR2X1_5/a_2_6# XOR2X1_5/Y vdd pfet w=40 l=2
+  ad=0 pd=0 as=0 ps=0
M3818 XOR2X1_5/a_13_43# invader_1_coord_x[3] vdd vdd pfet w=40 l=2
+  ad=0.2n pd=90u as=0 ps=0
M3819 gnd invader_1_coord_x[3] XOR2X1_5/a_35_6# Gnd nfet w=20 l=2
+  ad=0 pd=0 as=0 ps=0
M3820 INVX2_123/Y INVX2_123/A gnd Gnd nfet w=20 l=2
+  ad=100p pd=50u as=0 ps=0
M3821 INVX2_123/Y INVX2_123/A vdd vdd pfet w=40 l=2
+  ad=0.2n pd=90u as=0 ps=0
M3822 XOR2X1_13/A INVX2_101/A gnd Gnd nfet w=20 l=2
+  ad=100p pd=50u as=0 ps=0
M3823 XOR2X1_13/A INVX2_101/A vdd vdd pfet w=40 l=2
+  ad=0.2n pd=90u as=0 ps=0
M3824 INVX2_112/Y INVX2_112/A gnd Gnd nfet w=20 l=2
+  ad=100p pd=50u as=0 ps=0
M3825 INVX2_112/Y INVX2_112/A vdd vdd pfet w=40 l=2
+  ad=0.2n pd=90u as=0 ps=0
M3826 INVX2_134/Y INVX2_134/A gnd Gnd nfet w=20 l=2
+  ad=100p pd=50u as=0 ps=0
M3827 INVX2_134/Y INVX2_134/A vdd vdd pfet w=40 l=2
+  ad=0.2n pd=90u as=0 ps=0
M3828 INVX2_145/Y INVX2_145/A gnd Gnd nfet w=20 l=2
+  ad=100p pd=50u as=0 ps=0
M3829 INVX2_145/Y INVX2_145/A vdd vdd pfet w=40 l=2
+  ad=0.2n pd=90u as=0 ps=0
M3830 INVX2_156/Y INVX2_156/A gnd Gnd nfet w=20 l=2
+  ad=100p pd=50u as=0 ps=0
M3831 INVX2_156/Y INVX2_156/A vdd vdd pfet w=40 l=2
+  ad=0.2n pd=90u as=0 ps=0
M3832 INVX2_167/Y INVX2_167/A gnd Gnd nfet w=20 l=2
+  ad=100p pd=50u as=0 ps=0
M3833 INVX2_167/Y INVX2_167/A vdd vdd pfet w=40 l=2
+  ad=0.2n pd=90u as=0 ps=0
M3834 INVX2_178/Y invader_1_coord_x[3] gnd Gnd nfet w=20 l=2
+  ad=100p pd=50u as=0 ps=0
M3835 INVX2_178/Y invader_1_coord_x[3] vdd vdd pfet w=40 l=2
+  ad=0.2n pd=90u as=0 ps=0
M3836 DFFNEGX1_18/a_76_6# BUFX2_6/Y DFFNEGX1_18/a_66_6# Gnd nfet w=10 l=2
+  ad=29.999998p pd=26u as=80p ps=36u
M3837 gnd BUFX2_6/Y DFFNEGX1_18/a_2_6# Gnd nfet w=20 l=2
+  ad=0 pd=0 as=100p ps=50u
M3838 DFFNEGX1_18/a_66_6# DFFNEGX1_18/a_2_6# DFFNEGX1_18/a_61_6# Gnd nfet w=10 l=2
+  ad=0 pd=0 as=29.999998p ps=26u
M3839 player_bullet_coord_x[1] DFFNEGX1_18/a_66_6# gnd Gnd nfet w=20 l=2
+  ad=100p pd=50u as=0 ps=0
M3840 DFFNEGX1_18/a_23_6# BUFX2_6/Y DFFNEGX1_18/a_17_6# Gnd nfet w=10 l=2
+  ad=59.999996p pd=32u as=40p ps=28u
M3841 DFFNEGX1_18/a_23_6# DFFNEGX1_18/a_2_6# DFFNEGX1_18/a_17_74# vdd pfet w=20 l=2
+  ad=0.12n pd=52u as=80p ps=48u
M3842 gnd DFFNEGX1_18/a_34_4# DFFNEGX1_18/a_31_6# Gnd nfet w=10 l=2
+  ad=0 pd=0 as=29.999998p ps=26u
M3843 vdd DFFNEGX1_18/a_34_4# DFFNEGX1_18/a_31_74# vdd pfet w=20 l=2
+  ad=0 pd=0 as=80p ps=48u
M3844 DFFNEGX1_18/a_61_74# DFFNEGX1_18/a_34_4# vdd vdd pfet w=20 l=2
+  ad=59.999996p pd=46u as=0 ps=0
M3845 DFFNEGX1_18/a_34_4# DFFNEGX1_18/a_23_6# vdd vdd pfet w=20 l=2
+  ad=100p pd=50u as=0 ps=0
M3846 DFFNEGX1_18/a_34_4# DFFNEGX1_18/a_23_6# gnd Gnd nfet w=10 l=2
+  ad=50p pd=30u as=0 ps=0
M3847 vdd player_bullet_coord_x[1] DFFNEGX1_18/a_76_84# vdd pfet w=10 l=2
+  ad=0 pd=0 as=29.999998p ps=26u
M3848 gnd player_bullet_coord_x[1] DFFNEGX1_18/a_76_6# Gnd nfet w=10 l=2
+  ad=0 pd=0 as=0 ps=0
M3849 DFFNEGX1_18/a_61_6# DFFNEGX1_18/a_34_4# gnd Gnd nfet w=10 l=2
+  ad=0 pd=0 as=0 ps=0
M3850 DFFNEGX1_18/a_76_84# DFFNEGX1_18/a_2_6# DFFNEGX1_18/a_66_6# vdd pfet w=10 l=2
+  ad=0 pd=0 as=0.15n ps=56u
M3851 player_bullet_coord_x[1] DFFNEGX1_18/a_66_6# vdd vdd pfet w=40 l=2
+  ad=0.2n pd=90u as=0 ps=0
M3852 vdd BUFX2_6/Y DFFNEGX1_18/a_2_6# vdd pfet w=40 l=2
+  ad=0 pd=0 as=0.2n ps=90u
M3853 DFFNEGX1_18/a_31_6# DFFNEGX1_18/a_2_6# DFFNEGX1_18/a_23_6# Gnd nfet w=10 l=2
+  ad=0 pd=0 as=0 ps=0
M3854 DFFNEGX1_18/a_66_6# BUFX2_6/Y DFFNEGX1_18/a_61_74# vdd pfet w=20 l=2
+  ad=0 pd=0 as=0 ps=0
M3855 DFFNEGX1_18/a_17_74# INVX2_141/Y vdd vdd pfet w=20 l=2
+  ad=0 pd=0 as=0 ps=0
M3856 DFFNEGX1_18/a_31_74# BUFX2_6/Y DFFNEGX1_18/a_23_6# vdd pfet w=20 l=2
+  ad=0 pd=0 as=0 ps=0
M3857 DFFNEGX1_18/a_17_6# INVX2_141/Y gnd Gnd nfet w=10 l=2
+  ad=0 pd=0 as=0 ps=0
M3858 DFFNEGX1_29/a_76_6# BUFX2_6/Y DFFNEGX1_29/a_66_6# Gnd nfet w=10 l=2
+  ad=29.999998p pd=26u as=80p ps=36u
M3859 gnd BUFX2_6/Y DFFNEGX1_29/a_2_6# Gnd nfet w=20 l=2
+  ad=0 pd=0 as=100p ps=50u
M3860 DFFNEGX1_29/a_66_6# DFFNEGX1_29/a_2_6# DFFNEGX1_29/a_61_6# Gnd nfet w=10 l=2
+  ad=0 pd=0 as=29.999998p ps=26u
M3861 INVX2_32/A DFFNEGX1_29/a_66_6# gnd Gnd nfet w=20 l=2
+  ad=100p pd=50u as=0 ps=0
M3862 DFFNEGX1_29/a_23_6# BUFX2_6/Y DFFNEGX1_29/a_17_6# Gnd nfet w=10 l=2
+  ad=59.999996p pd=32u as=40p ps=28u
M3863 DFFNEGX1_29/a_23_6# DFFNEGX1_29/a_2_6# DFFNEGX1_29/a_17_74# vdd pfet w=20 l=2
+  ad=0.12n pd=52u as=80p ps=48u
M3864 gnd DFFNEGX1_29/a_34_4# DFFNEGX1_29/a_31_6# Gnd nfet w=10 l=2
+  ad=0 pd=0 as=29.999998p ps=26u
M3865 vdd DFFNEGX1_29/a_34_4# DFFNEGX1_29/a_31_74# vdd pfet w=20 l=2
+  ad=0 pd=0 as=80p ps=48u
M3866 DFFNEGX1_29/a_61_74# DFFNEGX1_29/a_34_4# vdd vdd pfet w=20 l=2
+  ad=59.999996p pd=46u as=0 ps=0
M3867 DFFNEGX1_29/a_34_4# DFFNEGX1_29/a_23_6# vdd vdd pfet w=20 l=2
+  ad=100p pd=50u as=0 ps=0
M3868 DFFNEGX1_29/a_34_4# DFFNEGX1_29/a_23_6# gnd Gnd nfet w=10 l=2
+  ad=50p pd=30u as=0 ps=0
M3869 vdd INVX2_32/A DFFNEGX1_29/a_76_84# vdd pfet w=10 l=2
+  ad=0 pd=0 as=29.999998p ps=26u
M3870 gnd INVX2_32/A DFFNEGX1_29/a_76_6# Gnd nfet w=10 l=2
+  ad=0 pd=0 as=0 ps=0
M3871 DFFNEGX1_29/a_61_6# DFFNEGX1_29/a_34_4# gnd Gnd nfet w=10 l=2
+  ad=0 pd=0 as=0 ps=0
M3872 DFFNEGX1_29/a_76_84# DFFNEGX1_29/a_2_6# DFFNEGX1_29/a_66_6# vdd pfet w=10 l=2
+  ad=0 pd=0 as=0.15n ps=56u
M3873 INVX2_32/A DFFNEGX1_29/a_66_6# vdd vdd pfet w=40 l=2
+  ad=0.2n pd=90u as=0 ps=0
M3874 vdd BUFX2_6/Y DFFNEGX1_29/a_2_6# vdd pfet w=40 l=2
+  ad=0 pd=0 as=0.2n ps=90u
M3875 DFFNEGX1_29/a_31_6# DFFNEGX1_29/a_2_6# DFFNEGX1_29/a_23_6# Gnd nfet w=10 l=2
+  ad=0 pd=0 as=0 ps=0
M3876 DFFNEGX1_29/a_66_6# BUFX2_6/Y DFFNEGX1_29/a_61_74# vdd pfet w=20 l=2
+  ad=0 pd=0 as=0 ps=0
M3877 DFFNEGX1_29/a_17_74# OAI22X1_4/Y vdd vdd pfet w=20 l=2
+  ad=0 pd=0 as=0 ps=0
M3878 DFFNEGX1_29/a_31_74# BUFX2_6/Y DFFNEGX1_29/a_23_6# vdd pfet w=20 l=2
+  ad=0 pd=0 as=0 ps=0
M3879 DFFNEGX1_29/a_17_6# OAI22X1_4/Y gnd Gnd nfet w=10 l=2
+  ad=0 pd=0 as=0 ps=0
M3880 gnd XOR2X1_16/A XOR2X1_16/a_2_6# Gnd nfet w=20 l=2
+  ad=0 pd=0 as=100p ps=50u
M3881 XOR2X1_16/Y XOR2X1_16/a_2_6# XOR2X1_16/a_18_6# Gnd nfet w=20 l=2
+  ad=0.2n pd=60u as=59.999996p ps=46u
M3882 XOR2X1_16/a_13_43# XOR2X1_18/Y gnd Gnd nfet w=20 l=2
+  ad=100p pd=50u as=0 ps=0
M3883 XOR2X1_16/a_18_54# XOR2X1_16/a_13_43# vdd vdd pfet w=40 l=2
+  ad=0.12n pd=86u as=0 ps=0
M3884 XOR2X1_16/a_35_6# XOR2X1_16/A XOR2X1_16/Y Gnd nfet w=20 l=2
+  ad=59.999996p pd=46u as=0 ps=0
M3885 XOR2X1_16/a_18_6# XOR2X1_16/a_13_43# gnd Gnd nfet w=20 l=2
+  ad=0 pd=0 as=0 ps=0
M3886 vdd XOR2X1_16/A XOR2X1_16/a_2_6# vdd pfet w=40 l=2
+  ad=0 pd=0 as=0.2n ps=90u
M3887 vdd XOR2X1_18/Y XOR2X1_16/a_35_54# vdd pfet w=40 l=2
+  ad=0 pd=0 as=0.12n ps=86u
M3888 XOR2X1_16/Y XOR2X1_16/A XOR2X1_16/a_18_54# vdd pfet w=40 l=2
+  ad=0.4n pd=100u as=0 ps=0
M3889 XOR2X1_16/a_35_54# XOR2X1_16/a_2_6# XOR2X1_16/Y vdd pfet w=40 l=2
+  ad=0 pd=0 as=0 ps=0
M3890 XOR2X1_16/a_13_43# XOR2X1_18/Y vdd vdd pfet w=40 l=2
+  ad=0.2n pd=90u as=0 ps=0
M3891 gnd XOR2X1_18/Y XOR2X1_16/a_35_6# Gnd nfet w=20 l=2
+  ad=0 pd=0 as=0 ps=0
M3892 NAND3X1_6/Y NAND3X1_6/A vdd vdd pfet w=20 l=2
+  ad=0.22n pd=0.102m as=0 ps=0
M3893 NAND3X1_6/a_9_6# NAND3X1_6/A gnd Gnd nfet w=30 l=2
+  ad=90p pd=66u as=0 ps=0
M3894 NAND3X1_6/Y player_bullet_coord_x[2] vdd vdd pfet w=20 l=2
+  ad=0 pd=0 as=0 ps=0
M3895 NAND3X1_6/Y player_bullet_coord_x[2] NAND3X1_6/a_14_6# Gnd nfet w=30 l=2
+  ad=0.15n pd=70u as=90p ps=66u
M3896 vdd INVX2_65/Y NAND3X1_6/Y vdd pfet w=20 l=2
+  ad=0 pd=0 as=0 ps=0
M3897 NAND3X1_6/a_14_6# INVX2_65/Y NAND3X1_6/a_9_6# Gnd nfet w=30 l=2
+  ad=0 pd=0 as=0 ps=0
M3898 gnd INVX2_176/Y OAI21X1_113/a_2_6# Gnd nfet w=20 l=2
+  ad=0 pd=0 as=0.22n ps=0.102m
M3899 vdd NOR2X1_46/Y NAND3X1_44/A vdd pfet w=20 l=2
+  ad=0 pd=0 as=0.22n ps=92u
M3900 NAND3X1_44/A NOR2X1_46/Y OAI21X1_113/a_2_6# Gnd nfet w=20 l=2
+  ad=100p pd=50u as=0 ps=0
M3901 NAND3X1_44/A OR2X1_17/A OAI21X1_113/a_9_54# vdd pfet w=40 l=2
+  ad=0 pd=0 as=0.12n ps=86u
M3902 OAI21X1_113/a_9_54# INVX2_176/Y vdd vdd pfet w=40 l=2
+  ad=0 pd=0 as=0 ps=0
M3903 OAI21X1_113/a_2_6# OR2X1_17/A gnd Gnd nfet w=20 l=2
+  ad=0 pd=0 as=0 ps=0
M3904 gnd INVX2_182/Y OAI21X1_102/a_2_6# Gnd nfet w=20 l=2
+  ad=0 pd=0 as=0.22n ps=0.102m
M3905 vdd NAND2X1_51/Y OAI21X1_102/Y vdd pfet w=20 l=2
+  ad=0 pd=0 as=0.22n ps=92u
M3906 OAI21X1_102/Y NAND2X1_51/Y OAI21X1_102/a_2_6# Gnd nfet w=20 l=2
+  ad=100p pd=50u as=0 ps=0
M3907 OAI21X1_102/Y INVX2_131/A OAI21X1_102/a_9_54# vdd pfet w=40 l=2
+  ad=0 pd=0 as=0.12n ps=86u
M3908 OAI21X1_102/a_9_54# INVX2_182/Y vdd vdd pfet w=40 l=2
+  ad=0 pd=0 as=0 ps=0
M3909 OAI21X1_102/a_2_6# INVX2_131/A gnd Gnd nfet w=20 l=2
+  ad=0 pd=0 as=0 ps=0
M3910 gnd player_coord_x[2] OAI21X1_146/a_2_6# Gnd nfet w=20 l=2
+  ad=0 pd=0 as=0.22n ps=0.102m
M3911 vdd XNOR2X1_7/B AOI21X1_31/B vdd pfet w=20 l=2
+  ad=0 pd=0 as=0.22n ps=92u
M3912 AOI21X1_31/B XNOR2X1_7/B OAI21X1_146/a_2_6# Gnd nfet w=20 l=2
+  ad=100p pd=50u as=0 ps=0
M3913 AOI21X1_31/B INVX2_64/Y OAI21X1_146/a_9_54# vdd pfet w=40 l=2
+  ad=0 pd=0 as=0.12n ps=86u
M3914 OAI21X1_146/a_9_54# player_coord_x[2] vdd vdd pfet w=40 l=2
+  ad=0 pd=0 as=0 ps=0
M3915 OAI21X1_146/a_2_6# INVX2_64/Y gnd Gnd nfet w=20 l=2
+  ad=0 pd=0 as=0 ps=0
M3916 gnd AND2X2_8/A OAI21X1_124/a_2_6# Gnd nfet w=20 l=2
+  ad=0 pd=0 as=0.22n ps=0.102m
M3917 vdd OAI21X1_125/Y OR2X1_18/B vdd pfet w=20 l=2
+  ad=0 pd=0 as=0.22n ps=92u
M3918 OR2X1_18/B OAI21X1_125/Y OAI21X1_124/a_2_6# Gnd nfet w=20 l=2
+  ad=100p pd=50u as=0 ps=0
M3919 OR2X1_18/B INVX2_127/A OAI21X1_124/a_9_54# vdd pfet w=40 l=2
+  ad=0 pd=0 as=0.12n ps=86u
M3920 OAI21X1_124/a_9_54# AND2X2_8/A vdd vdd pfet w=40 l=2
+  ad=0 pd=0 as=0 ps=0
M3921 OAI21X1_124/a_2_6# INVX2_127/A gnd Gnd nfet w=20 l=2
+  ad=0 pd=0 as=0 ps=0
M3922 gnd INVX2_108/Y OAI21X1_135/a_2_6# Gnd nfet w=20 l=2
+  ad=0 pd=0 as=0.22n ps=0.102m
M3923 vdd OAI21X1_136/Y OAI21X1_135/Y vdd pfet w=20 l=2
+  ad=0 pd=0 as=0.22n ps=92u
M3924 OAI21X1_135/Y OAI21X1_136/Y OAI21X1_135/a_2_6# Gnd nfet w=20 l=2
+  ad=100p pd=50u as=0 ps=0
M3925 OAI21X1_135/Y INVX2_112/A OAI21X1_135/a_9_54# vdd pfet w=40 l=2
+  ad=0 pd=0 as=0.12n ps=86u
M3926 OAI21X1_135/a_9_54# INVX2_108/Y vdd vdd pfet w=40 l=2
+  ad=0 pd=0 as=0 ps=0
M3927 OAI21X1_135/a_2_6# INVX2_112/A gnd Gnd nfet w=20 l=2
+  ad=0 pd=0 as=0 ps=0
M3928 vdd clkb BUFX2_0/a_2_6# vdd pfet w=20 l=2
+  ad=0.11n pd=46u as=100p ps=50u
M3929 gnd clkb BUFX2_0/a_2_6# Gnd nfet w=10 l=2
+  ad=55p pd=26u as=50p ps=30u
M3930 BUFX2_4/A BUFX2_0/a_2_6# vdd vdd pfet w=40 l=2
+  ad=0.2n pd=90u as=0.11n ps=46u
M3931 BUFX2_4/A BUFX2_0/a_2_6# gnd Gnd nfet w=20 l=2
+  ad=100p pd=50u as=55p ps=26u
M3932 INVX2_0/Y invader_bullet_coord_y[0] gnd Gnd nfet w=20 l=2
+  ad=100p pd=50u as=0 ps=0
M3933 INVX2_0/Y invader_bullet_coord_y[0] vdd vdd pfet w=40 l=2
+  ad=0.2n pd=90u as=0 ps=0
M3934 gnd INVX2_117/Y AOI22X1_19/a_28_6# Gnd nfet w=20 l=2
+  ad=0 pd=0 as=59.999996p ps=46u
M3935 NOR2X1_1/A XNOR2X1_0/Y AOI22X1_19/a_11_6# Gnd nfet w=20 l=2
+  ad=0.2n pd=60u as=59.999996p ps=46u
M3936 AOI22X1_19/a_11_6# INVX2_2/A gnd Gnd nfet w=20 l=2
+  ad=0 pd=0 as=0 ps=0
M3937 AOI22X1_19/a_2_54# XNOR2X1_0/Y vdd vdd pfet w=40 l=2
+  ad=0.64n pd=0.272m as=0 ps=0
M3938 AOI22X1_19/a_28_6# INVX2_2/Y NOR2X1_1/A Gnd nfet w=20 l=2
+  ad=0 pd=0 as=0 ps=0
M3939 vdd INVX2_2/A AOI22X1_19/a_2_54# vdd pfet w=40 l=2
+  ad=0 pd=0 as=0 ps=0
M3940 NOR2X1_1/A INVX2_2/Y AOI22X1_19/a_2_54# vdd pfet w=40 l=2
+  ad=0.24n pd=92u as=0 ps=0
M3941 AOI22X1_19/a_2_54# INVX2_117/Y NOR2X1_1/A vdd pfet w=40 l=2
+  ad=0 pd=0 as=0 ps=0
M3942 AOI21X1_0/a_2_54# AOI21X1_0/B vdd vdd pfet w=40 l=2
+  ad=0.12n pd=46u as=0.12n ps=46u
M3943 AOI21X1_0/a_12_6# INVX2_2/A gnd Gnd nfet w=20 l=2
+  ad=29.999998p pd=23u as=100p ps=50u
M3944 gnd AOI21X1_0/C INVX2_143/A Gnd nfet w=10 l=2
+  ad=50p pd=30u as=55p ps=26u
M3945 vdd INVX2_2/A AOI21X1_0/a_2_54# vdd pfet w=40 l=2
+  ad=0.12n pd=46u as=0.2n ps=90u
M3946 INVX2_143/A AOI21X1_0/C AOI21X1_0/a_2_54# vdd pfet w=40 l=2
+  ad=0.2n pd=90u as=0.12n ps=46u
M3947 INVX2_143/A AOI21X1_0/B AOI21X1_0/a_12_6# Gnd nfet w=20 l=2
+  ad=55p pd=26u as=29.999998p ps=23u
M3948 vdd invader_1_coord_x[1] HAX1_11/a_2_74# vdd pfet w=20 l=2
+  ad=0 pd=0 as=0.2n ps=100u
M3949 HAX1_11/a_41_74# HAX1_11/a_2_74# vdd vdd pfet w=20 l=2
+  ad=0.22n pd=92u as=0 ps=0
M3950 HAX1_11/a_9_6# invader_1_coord_x[1] gnd Gnd nfet w=20 l=2
+  ad=59.999996p pd=46u as=0 ps=0
M3951 HAX1_11/a_41_74# invader_1_coord_x[0] HAX1_11/a_38_6# Gnd nfet w=20 l=2
+  ad=0.12n pd=52u as=0.216n ps=0.102m
M3952 vdd invader_1_coord_x[1] HAX1_11/a_49_54# vdd pfet w=40 l=2
+  ad=0 pd=0 as=0.12n ps=86u
M3953 vdd HAX1_11/a_2_74# HAX1_10/B vdd pfet w=20 l=2
+  ad=0 pd=0 as=100p ps=50u
M3954 HAX1_11/a_38_6# HAX1_11/a_2_74# gnd Gnd nfet w=20 l=2
+  ad=0 pd=0 as=0 ps=0
M3955 INVX2_62/A HAX1_11/a_41_74# vdd vdd pfet w=20 l=2
+  ad=100p pd=50u as=0 ps=0
M3956 HAX1_11/a_38_6# invader_1_coord_x[1] HAX1_11/a_41_74# Gnd nfet w=20 l=2
+  ad=0 pd=0 as=0 ps=0
M3957 INVX2_62/A HAX1_11/a_41_74# gnd Gnd nfet w=10 l=2
+  ad=50p pd=30u as=0 ps=0
M3958 HAX1_11/a_2_74# invader_1_coord_x[0] vdd vdd pfet w=20 l=2
+  ad=0 pd=0 as=0 ps=0
M3959 HAX1_11/a_2_74# invader_1_coord_x[0] HAX1_11/a_9_6# Gnd nfet w=20 l=2
+  ad=100p pd=50u as=0 ps=0
M3960 HAX1_11/a_49_54# invader_1_coord_x[0] HAX1_11/a_41_74# vdd pfet w=40 l=2
+  ad=0 pd=0 as=0 ps=0
M3961 gnd HAX1_11/a_2_74# HAX1_10/B Gnd nfet w=10 l=2
+  ad=0 pd=0 as=50p ps=30u
M3962 AOI21X1_30/a_2_54# AOI21X1_30/B vdd vdd pfet w=40 l=2
+  ad=0.44n pd=0.182m as=0 ps=0
M3963 AOI21X1_30/a_12_6# NAND2X1_74/Y gnd Gnd nfet w=20 l=2
+  ad=59.999996p pd=46u as=0 ps=0
M3964 gnd INVX2_106/Y AOI22X1_60/C Gnd nfet w=10 l=2
+  ad=0 pd=0 as=0.11n ps=52u
M3965 vdd NAND2X1_74/Y AOI21X1_30/a_2_54# vdd pfet w=40 l=2
+  ad=0 pd=0 as=0 ps=0
M3966 AOI22X1_60/C INVX2_106/Y AOI21X1_30/a_2_54# vdd pfet w=40 l=2
+  ad=0.2n pd=90u as=0 ps=0
M3967 AOI22X1_60/C AOI21X1_30/B AOI21X1_30/a_12_6# Gnd nfet w=20 l=2
+  ad=0 pd=0 as=0 ps=0
M3968 gnd INVX2_51/A OAI21X1_3/a_2_6# Gnd nfet w=20 l=2
+  ad=0 pd=0 as=0.22n ps=0.102m
M3969 vdd INVX2_52/Y OAI21X1_3/Y vdd pfet w=20 l=2
+  ad=0 pd=0 as=0.22n ps=92u
M3970 OAI21X1_3/Y INVX2_52/Y OAI21X1_3/a_2_6# Gnd nfet w=20 l=2
+  ad=100p pd=50u as=0 ps=0
M3971 OAI21X1_3/Y OAI21X1_4/Y OAI21X1_3/a_9_54# vdd pfet w=40 l=2
+  ad=0 pd=0 as=0.12n ps=86u
M3972 OAI21X1_3/a_9_54# INVX2_51/A vdd vdd pfet w=40 l=2
+  ad=0 pd=0 as=0 ps=0
M3973 OAI21X1_3/a_2_6# OAI21X1_4/Y gnd Gnd nfet w=20 l=2
+  ad=0 pd=0 as=0 ps=0
M3974 DFFNEGX1_1/a_76_6# BUFX2_7/Y DFFNEGX1_1/a_66_6# Gnd nfet w=10 l=2
+  ad=29.999998p pd=26u as=80p ps=36u
M3975 gnd BUFX2_7/Y DFFNEGX1_1/a_2_6# Gnd nfet w=20 l=2
+  ad=0 pd=0 as=100p ps=50u
M3976 DFFNEGX1_1/a_66_6# DFFNEGX1_1/a_2_6# DFFNEGX1_1/a_61_6# Gnd nfet w=10 l=2
+  ad=0 pd=0 as=29.999998p ps=26u
M3977 invader_bullet_coord_y[3] DFFNEGX1_1/a_66_6# gnd Gnd nfet w=20 l=2
+  ad=100p pd=50u as=0 ps=0
M3978 DFFNEGX1_1/a_23_6# BUFX2_7/Y DFFNEGX1_1/a_17_6# Gnd nfet w=10 l=2
+  ad=59.999996p pd=32u as=40p ps=28u
M3979 DFFNEGX1_1/a_23_6# DFFNEGX1_1/a_2_6# DFFNEGX1_1/a_17_74# vdd pfet w=20 l=2
+  ad=0.12n pd=52u as=80p ps=48u
M3980 gnd DFFNEGX1_1/a_34_4# DFFNEGX1_1/a_31_6# Gnd nfet w=10 l=2
+  ad=0 pd=0 as=29.999998p ps=26u
M3981 vdd DFFNEGX1_1/a_34_4# DFFNEGX1_1/a_31_74# vdd pfet w=20 l=2
+  ad=0 pd=0 as=80p ps=48u
M3982 DFFNEGX1_1/a_61_74# DFFNEGX1_1/a_34_4# vdd vdd pfet w=20 l=2
+  ad=59.999996p pd=46u as=0 ps=0
M3983 DFFNEGX1_1/a_34_4# DFFNEGX1_1/a_23_6# vdd vdd pfet w=20 l=2
+  ad=100p pd=50u as=0 ps=0
M3984 DFFNEGX1_1/a_34_4# DFFNEGX1_1/a_23_6# gnd Gnd nfet w=10 l=2
+  ad=50p pd=30u as=0 ps=0
M3985 vdd invader_bullet_coord_y[3] DFFNEGX1_1/a_76_84# vdd pfet w=10 l=2
+  ad=0 pd=0 as=29.999998p ps=26u
M3986 gnd invader_bullet_coord_y[3] DFFNEGX1_1/a_76_6# Gnd nfet w=10 l=2
+  ad=0 pd=0 as=0 ps=0
M3987 DFFNEGX1_1/a_61_6# DFFNEGX1_1/a_34_4# gnd Gnd nfet w=10 l=2
+  ad=0 pd=0 as=0 ps=0
M3988 DFFNEGX1_1/a_76_84# DFFNEGX1_1/a_2_6# DFFNEGX1_1/a_66_6# vdd pfet w=10 l=2
+  ad=0 pd=0 as=0.15n ps=56u
M3989 invader_bullet_coord_y[3] DFFNEGX1_1/a_66_6# vdd vdd pfet w=40 l=2
+  ad=0.2n pd=90u as=0 ps=0
M3990 vdd BUFX2_7/Y DFFNEGX1_1/a_2_6# vdd pfet w=40 l=2
+  ad=0 pd=0 as=0.2n ps=90u
M3991 DFFNEGX1_1/a_31_6# DFFNEGX1_1/a_2_6# DFFNEGX1_1/a_23_6# Gnd nfet w=10 l=2
+  ad=0 pd=0 as=0 ps=0
M3992 DFFNEGX1_1/a_66_6# BUFX2_7/Y DFFNEGX1_1/a_61_74# vdd pfet w=20 l=2
+  ad=0 pd=0 as=0 ps=0
M3993 DFFNEGX1_1/a_17_74# NAND2X1_0/Y vdd vdd pfet w=20 l=2
+  ad=0 pd=0 as=0 ps=0
M3994 DFFNEGX1_1/a_31_74# BUFX2_7/Y DFFNEGX1_1/a_23_6# vdd pfet w=20 l=2
+  ad=0 pd=0 as=0 ps=0
M3995 DFFNEGX1_1/a_17_6# NAND2X1_0/Y gnd Gnd nfet w=10 l=2
+  ad=0 pd=0 as=0 ps=0
M3996 gnd invader_1_coord_x[1] XOR2X1_6/a_2_6# Gnd nfet w=20 l=2
+  ad=0 pd=0 as=100p ps=50u
M3997 XOR2X1_6/Y XOR2X1_6/a_2_6# XOR2X1_6/a_18_6# Gnd nfet w=20 l=2
+  ad=0.2n pd=60u as=59.999996p ps=46u
M3998 XOR2X1_6/a_13_43# invader_1_coord_x[2] gnd Gnd nfet w=20 l=2
+  ad=100p pd=50u as=0 ps=0
M3999 XOR2X1_6/a_18_54# XOR2X1_6/a_13_43# vdd vdd pfet w=40 l=2
+  ad=0.12n pd=86u as=0 ps=0
M4000 XOR2X1_6/a_35_6# invader_1_coord_x[1] XOR2X1_6/Y Gnd nfet w=20 l=2
+  ad=59.999996p pd=46u as=0 ps=0
M4001 XOR2X1_6/a_18_6# XOR2X1_6/a_13_43# gnd Gnd nfet w=20 l=2
+  ad=0 pd=0 as=0 ps=0
M4002 vdd invader_1_coord_x[1] XOR2X1_6/a_2_6# vdd pfet w=40 l=2
+  ad=0 pd=0 as=0.2n ps=90u
M4003 vdd invader_1_coord_x[2] XOR2X1_6/a_35_54# vdd pfet w=40 l=2
+  ad=0 pd=0 as=0.12n ps=86u
M4004 XOR2X1_6/Y invader_1_coord_x[1] XOR2X1_6/a_18_54# vdd pfet w=40 l=2
+  ad=0.4n pd=100u as=0 ps=0
M4005 XOR2X1_6/a_35_54# XOR2X1_6/a_2_6# XOR2X1_6/Y vdd pfet w=40 l=2
+  ad=0 pd=0 as=0 ps=0
M4006 XOR2X1_6/a_13_43# invader_1_coord_x[2] vdd vdd pfet w=40 l=2
+  ad=0.2n pd=90u as=0 ps=0
M4007 gnd invader_1_coord_x[2] XOR2X1_6/a_35_6# Gnd nfet w=20 l=2
+  ad=0 pd=0 as=0 ps=0
M4008 INVX2_113/Y INVX2_113/A gnd Gnd nfet w=20 l=2
+  ad=100p pd=50u as=0 ps=0
M4009 INVX2_113/Y INVX2_113/A vdd vdd pfet w=40 l=2
+  ad=0.2n pd=90u as=0 ps=0
M4010 XOR2X1_16/A INVX2_102/A gnd Gnd nfet w=20 l=2
+  ad=100p pd=50u as=0 ps=0
M4011 XOR2X1_16/A INVX2_102/A vdd vdd pfet w=40 l=2
+  ad=0.2n pd=90u as=0 ps=0
M4012 INVX2_124/Y INVX2_124/A gnd Gnd nfet w=20 l=2
+  ad=100p pd=50u as=0 ps=0
M4013 INVX2_124/Y INVX2_124/A vdd vdd pfet w=40 l=2
+  ad=0.2n pd=90u as=0 ps=0
M4014 INVX2_146/Y INVX2_146/A gnd Gnd nfet w=20 l=2
+  ad=100p pd=50u as=0 ps=0
M4015 INVX2_146/Y INVX2_146/A vdd vdd pfet w=40 l=2
+  ad=0.2n pd=90u as=0 ps=0
M4016 INVX2_135/Y INVX2_135/A gnd Gnd nfet w=20 l=2
+  ad=100p pd=50u as=0 ps=0
M4017 INVX2_135/Y INVX2_135/A vdd vdd pfet w=40 l=2
+  ad=0.2n pd=90u as=0 ps=0
M4018 INVX2_168/Y NOR2X1_60/B gnd Gnd nfet w=20 l=2
+  ad=100p pd=50u as=0 ps=0
M4019 INVX2_168/Y NOR2X1_60/B vdd vdd pfet w=40 l=2
+  ad=0.2n pd=90u as=0 ps=0
M4020 AND2X2_7/B invader_2_coord_x[3] gnd Gnd nfet w=20 l=2
+  ad=100p pd=50u as=0 ps=0
M4021 AND2X2_7/B invader_2_coord_x[3] vdd vdd pfet w=40 l=2
+  ad=0.2n pd=90u as=0 ps=0
M4022 INVX2_157/Y INVX2_157/A gnd Gnd nfet w=20 l=2
+  ad=100p pd=50u as=0 ps=0
M4023 INVX2_157/Y INVX2_157/A vdd vdd pfet w=40 l=2
+  ad=0.2n pd=90u as=0 ps=0
M4024 DFFNEGX1_19/a_76_6# BUFX2_6/Y DFFNEGX1_19/a_66_6# Gnd nfet w=10 l=2
+  ad=29.999998p pd=26u as=80p ps=36u
M4025 gnd BUFX2_6/Y DFFNEGX1_19/a_2_6# Gnd nfet w=20 l=2
+  ad=0 pd=0 as=100p ps=50u
M4026 DFFNEGX1_19/a_66_6# DFFNEGX1_19/a_2_6# DFFNEGX1_19/a_61_6# Gnd nfet w=10 l=2
+  ad=0 pd=0 as=29.999998p ps=26u
M4027 player_bullet_coord_x[0] DFFNEGX1_19/a_66_6# gnd Gnd nfet w=20 l=2
+  ad=100p pd=50u as=0 ps=0
M4028 DFFNEGX1_19/a_23_6# BUFX2_6/Y DFFNEGX1_19/a_17_6# Gnd nfet w=10 l=2
+  ad=59.999996p pd=32u as=40p ps=28u
M4029 DFFNEGX1_19/a_23_6# DFFNEGX1_19/a_2_6# DFFNEGX1_19/a_17_74# vdd pfet w=20 l=2
+  ad=0.12n pd=52u as=80p ps=48u
M4030 gnd DFFNEGX1_19/a_34_4# DFFNEGX1_19/a_31_6# Gnd nfet w=10 l=2
+  ad=0 pd=0 as=29.999998p ps=26u
M4031 vdd DFFNEGX1_19/a_34_4# DFFNEGX1_19/a_31_74# vdd pfet w=20 l=2
+  ad=0 pd=0 as=80p ps=48u
M4032 DFFNEGX1_19/a_61_74# DFFNEGX1_19/a_34_4# vdd vdd pfet w=20 l=2
+  ad=59.999996p pd=46u as=0 ps=0
M4033 DFFNEGX1_19/a_34_4# DFFNEGX1_19/a_23_6# vdd vdd pfet w=20 l=2
+  ad=100p pd=50u as=0 ps=0
M4034 DFFNEGX1_19/a_34_4# DFFNEGX1_19/a_23_6# gnd Gnd nfet w=10 l=2
+  ad=50p pd=30u as=0 ps=0
M4035 vdd player_bullet_coord_x[0] DFFNEGX1_19/a_76_84# vdd pfet w=10 l=2
+  ad=0 pd=0 as=29.999998p ps=26u
M4036 gnd player_bullet_coord_x[0] DFFNEGX1_19/a_76_6# Gnd nfet w=10 l=2
+  ad=0 pd=0 as=0 ps=0
M4037 DFFNEGX1_19/a_61_6# DFFNEGX1_19/a_34_4# gnd Gnd nfet w=10 l=2
+  ad=0 pd=0 as=0 ps=0
M4038 DFFNEGX1_19/a_76_84# DFFNEGX1_19/a_2_6# DFFNEGX1_19/a_66_6# vdd pfet w=10 l=2
+  ad=0 pd=0 as=0.15n ps=56u
M4039 player_bullet_coord_x[0] DFFNEGX1_19/a_66_6# vdd vdd pfet w=40 l=2
+  ad=0.2n pd=90u as=0 ps=0
M4040 vdd BUFX2_6/Y DFFNEGX1_19/a_2_6# vdd pfet w=40 l=2
+  ad=0 pd=0 as=0.2n ps=90u
M4041 DFFNEGX1_19/a_31_6# DFFNEGX1_19/a_2_6# DFFNEGX1_19/a_23_6# Gnd nfet w=10 l=2
+  ad=0 pd=0 as=0 ps=0
M4042 DFFNEGX1_19/a_66_6# BUFX2_6/Y DFFNEGX1_19/a_61_74# vdd pfet w=20 l=2
+  ad=0 pd=0 as=0 ps=0
M4043 DFFNEGX1_19/a_17_74# INVX2_140/Y vdd vdd pfet w=20 l=2
+  ad=0 pd=0 as=0 ps=0
M4044 DFFNEGX1_19/a_31_74# BUFX2_6/Y DFFNEGX1_19/a_23_6# vdd pfet w=20 l=2
+  ad=0 pd=0 as=0 ps=0
M4045 DFFNEGX1_19/a_17_6# INVX2_140/Y gnd Gnd nfet w=10 l=2
+  ad=0 pd=0 as=0 ps=0
M4046 gnd XOR2X1_17/A XOR2X1_17/a_2_6# Gnd nfet w=20 l=2
+  ad=0 pd=0 as=100p ps=50u
M4047 XOR2X1_17/Y XOR2X1_17/a_2_6# XOR2X1_17/a_18_6# Gnd nfet w=20 l=2
+  ad=0.2n pd=60u as=59.999996p ps=46u
M4048 XOR2X1_17/a_13_43# XOR2X1_18/Y gnd Gnd nfet w=20 l=2
+  ad=100p pd=50u as=0 ps=0
M4049 XOR2X1_17/a_18_54# XOR2X1_17/a_13_43# vdd vdd pfet w=40 l=2
+  ad=0.12n pd=86u as=0 ps=0
M4050 XOR2X1_17/a_35_6# XOR2X1_17/A XOR2X1_17/Y Gnd nfet w=20 l=2
+  ad=59.999996p pd=46u as=0 ps=0
M4051 XOR2X1_17/a_18_6# XOR2X1_17/a_13_43# gnd Gnd nfet w=20 l=2
+  ad=0 pd=0 as=0 ps=0
M4052 vdd XOR2X1_17/A XOR2X1_17/a_2_6# vdd pfet w=40 l=2
+  ad=0 pd=0 as=0.2n ps=90u
M4053 vdd XOR2X1_18/Y XOR2X1_17/a_35_54# vdd pfet w=40 l=2
+  ad=0 pd=0 as=0.12n ps=86u
M4054 XOR2X1_17/Y XOR2X1_17/A XOR2X1_17/a_18_54# vdd pfet w=40 l=2
+  ad=0.4n pd=100u as=0 ps=0
M4055 XOR2X1_17/a_35_54# XOR2X1_17/a_2_6# XOR2X1_17/Y vdd pfet w=40 l=2
+  ad=0 pd=0 as=0 ps=0
M4056 XOR2X1_17/a_13_43# XOR2X1_18/Y vdd vdd pfet w=40 l=2
+  ad=0.2n pd=90u as=0 ps=0
M4057 gnd XOR2X1_18/Y XOR2X1_17/a_35_6# Gnd nfet w=20 l=2
+  ad=0 pd=0 as=0 ps=0
M4058 NAND3X1_7/Y NAND3X1_7/A vdd vdd pfet w=20 l=2
+  ad=0.22n pd=0.102m as=0 ps=0
M4059 NAND3X1_7/a_9_6# NAND3X1_7/A gnd Gnd nfet w=30 l=2
+  ad=90p pd=66u as=0 ps=0
M4060 NAND3X1_7/Y HAX1_7/YS vdd vdd pfet w=20 l=2
+  ad=0 pd=0 as=0 ps=0
M4061 NAND3X1_7/Y HAX1_7/YS NAND3X1_7/a_14_6# Gnd nfet w=30 l=2
+  ad=0.15n pd=70u as=90p ps=66u
M4062 vdd INVX2_15/Y NAND3X1_7/Y vdd pfet w=20 l=2
+  ad=0 pd=0 as=0 ps=0
M4063 NAND3X1_7/a_14_6# INVX2_15/Y NAND3X1_7/a_9_6# Gnd nfet w=30 l=2
+  ad=0 pd=0 as=0 ps=0
M4064 gnd INVX2_175/Y OAI21X1_103/a_2_6# Gnd nfet w=20 l=2
+  ad=0 pd=0 as=0.22n ps=0.102m
M4065 vdd INVX2_162/Y AOI22X1_39/D vdd pfet w=20 l=2
+  ad=0 pd=0 as=0.22n ps=92u
M4066 AOI22X1_39/D INVX2_162/Y OAI21X1_103/a_2_6# Gnd nfet w=20 l=2
+  ad=100p pd=50u as=0 ps=0
M4067 AOI22X1_39/D INVX2_161/A OAI21X1_103/a_9_54# vdd pfet w=40 l=2
+  ad=0 pd=0 as=0.12n ps=86u
M4068 OAI21X1_103/a_9_54# INVX2_175/Y vdd vdd pfet w=40 l=2
+  ad=0 pd=0 as=0 ps=0
M4069 OAI21X1_103/a_2_6# INVX2_161/A gnd Gnd nfet w=20 l=2
+  ad=0 pd=0 as=0 ps=0
M4070 gnd invader_1_coord_x[1] OAI21X1_147/a_2_6# Gnd nfet w=20 l=2
+  ad=0 pd=0 as=0.22n ps=0.102m
M4071 vdd OAI21X1_148/Y XNOR2X1_7/B vdd pfet w=20 l=2
+  ad=0 pd=0 as=0.22n ps=92u
M4072 XNOR2X1_7/B OAI21X1_148/Y OAI21X1_147/a_2_6# Gnd nfet w=20 l=2
+  ad=100p pd=50u as=0 ps=0
M4073 XNOR2X1_7/B XOR2X1_16/A OAI21X1_147/a_9_54# vdd pfet w=40 l=2
+  ad=0 pd=0 as=0.12n ps=86u
M4074 OAI21X1_147/a_9_54# invader_1_coord_x[1] vdd vdd pfet w=40 l=2
+  ad=0 pd=0 as=0 ps=0
M4075 OAI21X1_147/a_2_6# XOR2X1_16/A gnd Gnd nfet w=20 l=2
+  ad=0 pd=0 as=0 ps=0
M4076 gnd INVX2_166/Y OAI21X1_125/a_2_6# Gnd nfet w=20 l=2
+  ad=0 pd=0 as=0.22n ps=0.102m
M4077 vdd AND2X2_8/A OAI21X1_125/Y vdd pfet w=20 l=2
+  ad=0 pd=0 as=0.22n ps=92u
M4078 OAI21X1_125/Y AND2X2_8/A OAI21X1_125/a_2_6# Gnd nfet w=20 l=2
+  ad=100p pd=50u as=0 ps=0
M4079 OAI21X1_125/Y NOR2X1_54/Y OAI21X1_125/a_9_54# vdd pfet w=40 l=2
+  ad=0 pd=0 as=0.12n ps=86u
M4080 OAI21X1_125/a_9_54# INVX2_166/Y vdd vdd pfet w=40 l=2
+  ad=0 pd=0 as=0 ps=0
M4081 OAI21X1_125/a_2_6# NOR2X1_54/Y gnd Gnd nfet w=20 l=2
+  ad=0 pd=0 as=0 ps=0
M4082 gnd invader_bullet_coord_x[3] OAI21X1_114/a_2_6# Gnd nfet w=20 l=2
+  ad=0 pd=0 as=0.22n ps=0.102m
M4083 vdd OAI21X1_115/Y AOI22X1_45/D vdd pfet w=20 l=2
+  ad=0 pd=0 as=0.22n ps=92u
M4084 AOI22X1_45/D OAI21X1_115/Y OAI21X1_114/a_2_6# Gnd nfet w=20 l=2
+  ad=100p pd=50u as=0 ps=0
M4085 AOI22X1_45/D INVX2_118/A OAI21X1_114/a_9_54# vdd pfet w=40 l=2
+  ad=0 pd=0 as=0.12n ps=86u
M4086 OAI21X1_114/a_9_54# invader_bullet_coord_x[3] vdd vdd pfet w=40 l=2
+  ad=0 pd=0 as=0 ps=0
M4087 OAI21X1_114/a_2_6# INVX2_118/A gnd Gnd nfet w=20 l=2
+  ad=0 pd=0 as=0 ps=0
M4088 gnd INVX2_111/Y OAI21X1_136/a_2_6# Gnd nfet w=20 l=2
+  ad=0 pd=0 as=0.22n ps=0.102m
M4089 vdd OAI22X1_9/Y OAI21X1_136/Y vdd pfet w=20 l=2
+  ad=0 pd=0 as=0.22n ps=92u
M4090 OAI21X1_136/Y OAI22X1_9/Y OAI21X1_136/a_2_6# Gnd nfet w=20 l=2
+  ad=100p pd=50u as=0 ps=0
M4091 OAI21X1_136/Y INVX2_107/A OAI21X1_136/a_9_54# vdd pfet w=40 l=2
+  ad=0 pd=0 as=0.12n ps=86u
M4092 OAI21X1_136/a_9_54# INVX2_111/Y vdd vdd pfet w=40 l=2
+  ad=0 pd=0 as=0 ps=0
M4093 OAI21X1_136/a_2_6# INVX2_107/A gnd Gnd nfet w=20 l=2
+  ad=0 pd=0 as=0 ps=0
M4094 vdd clkb BUFX2_1/a_2_6# vdd pfet w=20 l=2
+  ad=0 pd=0 as=100p ps=50u
M4095 gnd clkb BUFX2_1/a_2_6# Gnd nfet w=10 l=2
+  ad=0 pd=0 as=50p ps=30u
M4096 BUFX2_7/A BUFX2_1/a_2_6# vdd vdd pfet w=40 l=2
+  ad=0.2n pd=90u as=0 ps=0
M4097 BUFX2_7/A BUFX2_1/a_2_6# gnd Gnd nfet w=20 l=2
+  ad=100p pd=50u as=0 ps=0
M4098 INVX2_1/Y invader_bullet_coord_y[3] gnd Gnd nfet w=20 l=2
+  ad=100p pd=50u as=0 ps=0
M4099 INVX2_1/Y invader_bullet_coord_y[3] vdd vdd pfet w=40 l=2
+  ad=0.2n pd=90u as=0 ps=0
M4100 AOI21X1_1/a_2_54# invader_2_coord_x[3] vdd vdd pfet w=40 l=2
+  ad=0.44n pd=0.182m as=0 ps=0
M4101 AOI21X1_1/a_12_6# NOR2X1_5/A gnd Gnd nfet w=20 l=2
+  ad=59.999996p pd=46u as=0 ps=0
M4102 gnd NOR2X1_5/Y INVX2_50/A Gnd nfet w=10 l=2
+  ad=0 pd=0 as=0.11n ps=52u
M4103 vdd NOR2X1_5/A AOI21X1_1/a_2_54# vdd pfet w=40 l=2
+  ad=0 pd=0 as=0 ps=0
M4104 INVX2_50/A NOR2X1_5/Y AOI21X1_1/a_2_54# vdd pfet w=40 l=2
+  ad=0.2n pd=90u as=0 ps=0
M4105 INVX2_50/A invader_2_coord_x[3] AOI21X1_1/a_12_6# Gnd nfet w=20 l=2
+  ad=0 pd=0 as=0 ps=0
M4106 AOI21X1_31/a_2_54# AOI21X1_31/B vdd vdd pfet w=40 l=2
+  ad=0.44n pd=0.182m as=0 ps=0
M4107 AOI21X1_31/a_12_6# NAND2X1_79/Y gnd Gnd nfet w=20 l=2
+  ad=59.999996p pd=46u as=0 ps=0
M4108 gnd INVX2_110/Y AOI22X1_62/C Gnd nfet w=10 l=2
+  ad=0 pd=0 as=0.11n ps=52u
M4109 vdd NAND2X1_79/Y AOI21X1_31/a_2_54# vdd pfet w=40 l=2
+  ad=0 pd=0 as=0 ps=0
M4110 AOI22X1_62/C INVX2_110/Y AOI21X1_31/a_2_54# vdd pfet w=40 l=2
+  ad=0.2n pd=90u as=0 ps=0
M4111 AOI22X1_62/C AOI21X1_31/B AOI21X1_31/a_12_6# Gnd nfet w=20 l=2
+  ad=0 pd=0 as=0 ps=0
M4112 vdd invader_2_coord_y[3] HAX1_12/a_2_74# vdd pfet w=20 l=2
+  ad=0 pd=0 as=0.2n ps=100u
M4113 HAX1_12/a_41_74# HAX1_12/a_2_74# vdd vdd pfet w=20 l=2
+  ad=0.22n pd=92u as=0 ps=0
M4114 HAX1_12/a_9_6# invader_2_coord_y[3] gnd Gnd nfet w=20 l=2
+  ad=59.999996p pd=46u as=0 ps=0
M4115 HAX1_12/a_41_74# HAX1_12/B HAX1_12/a_38_6# Gnd nfet w=20 l=2
+  ad=0.12n pd=52u as=0.216n ps=0.102m
M4116 vdd invader_2_coord_y[3] HAX1_12/a_49_54# vdd pfet w=40 l=2
+  ad=0 pd=0 as=0.12n ps=86u
M4117 vdd HAX1_12/a_2_74# OR2X1_1/B vdd pfet w=20 l=2
+  ad=0 pd=0 as=100p ps=50u
M4118 HAX1_12/a_38_6# HAX1_12/a_2_74# gnd Gnd nfet w=20 l=2
+  ad=0 pd=0 as=0 ps=0
M4119 INVX2_39/A HAX1_12/a_41_74# vdd vdd pfet w=20 l=2
+  ad=100p pd=50u as=0 ps=0
M4120 HAX1_12/a_38_6# invader_2_coord_y[3] HAX1_12/a_41_74# Gnd nfet w=20 l=2
+  ad=0 pd=0 as=0 ps=0
M4121 INVX2_39/A HAX1_12/a_41_74# gnd Gnd nfet w=10 l=2
+  ad=50p pd=30u as=0 ps=0
M4122 HAX1_12/a_2_74# HAX1_12/B vdd vdd pfet w=20 l=2
+  ad=0 pd=0 as=0 ps=0
M4123 HAX1_12/a_2_74# HAX1_12/B HAX1_12/a_9_6# Gnd nfet w=20 l=2
+  ad=100p pd=50u as=0 ps=0
M4124 HAX1_12/a_49_54# HAX1_12/B HAX1_12/a_41_74# vdd pfet w=40 l=2
+  ad=0 pd=0 as=0 ps=0
M4125 gnd HAX1_12/a_2_74# OR2X1_1/B Gnd nfet w=10 l=2
+  ad=0 pd=0 as=50p ps=30u
M4126 AOI21X1_20/a_2_54# OR2X1_17/A vdd vdd pfet w=40 l=2
+  ad=0.44n pd=0.182m as=0 ps=0
M4127 AOI21X1_20/a_12_6# INVX2_8/A gnd Gnd nfet w=20 l=2
+  ad=59.999996p pd=46u as=0 ps=0
M4128 gnd AOI22X1_17/Y AOI22X1_16/A Gnd nfet w=10 l=2
+  ad=0 pd=0 as=0.11n ps=52u
M4129 vdd INVX2_8/A AOI21X1_20/a_2_54# vdd pfet w=40 l=2
+  ad=0 pd=0 as=0 ps=0
M4130 AOI22X1_16/A AOI22X1_17/Y AOI21X1_20/a_2_54# vdd pfet w=40 l=2
+  ad=0.2n pd=90u as=0 ps=0
M4131 AOI22X1_16/A OR2X1_17/A AOI21X1_20/a_12_6# Gnd nfet w=20 l=2
+  ad=0 pd=0 as=0 ps=0
M4132 gnd INVX2_47/Y OAI21X1_4/a_2_6# Gnd nfet w=20 l=2
+  ad=0 pd=0 as=0.22n ps=0.102m
M4133 vdd OAI22X1_0/Y OAI21X1_4/Y vdd pfet w=20 l=2
+  ad=0 pd=0 as=0.22n ps=92u
M4134 OAI21X1_4/Y OAI22X1_0/Y OAI21X1_4/a_2_6# Gnd nfet w=20 l=2
+  ad=100p pd=50u as=0 ps=0
M4135 OAI21X1_4/Y OAI21X1_4/B OAI21X1_4/a_9_54# vdd pfet w=40 l=2
+  ad=0 pd=0 as=0.12n ps=86u
M4136 OAI21X1_4/a_9_54# INVX2_47/Y vdd vdd pfet w=40 l=2
+  ad=0 pd=0 as=0 ps=0
M4137 OAI21X1_4/a_2_6# OAI21X1_4/B gnd Gnd nfet w=20 l=2
+  ad=0 pd=0 as=0 ps=0
M4138 DFFNEGX1_2/a_76_6# clka DFFNEGX1_2/a_66_6# Gnd nfet w=10 l=2
+  ad=29.999998p pd=26u as=80p ps=36u
M4139 gnd clka DFFNEGX1_2/a_2_6# Gnd nfet w=20 l=2
+  ad=0 pd=0 as=100p ps=50u
M4140 DFFNEGX1_2/a_66_6# DFFNEGX1_2/a_2_6# DFFNEGX1_2/a_61_6# Gnd nfet w=10 l=2
+  ad=0 pd=0 as=29.999998p ps=26u
M4141 INVX2_2/A DFFNEGX1_2/a_66_6# gnd Gnd nfet w=20 l=2
+  ad=100p pd=50u as=0 ps=0
M4142 DFFNEGX1_2/a_23_6# clka DFFNEGX1_2/a_17_6# Gnd nfet w=10 l=2
+  ad=59.999996p pd=32u as=40p ps=28u
M4143 DFFNEGX1_2/a_23_6# DFFNEGX1_2/a_2_6# DFFNEGX1_2/a_17_74# vdd pfet w=20 l=2
+  ad=0.12n pd=52u as=80p ps=48u
M4144 gnd DFFNEGX1_2/a_34_4# DFFNEGX1_2/a_31_6# Gnd nfet w=10 l=2
+  ad=0 pd=0 as=29.999998p ps=26u
M4145 vdd DFFNEGX1_2/a_34_4# DFFNEGX1_2/a_31_74# vdd pfet w=20 l=2
+  ad=0 pd=0 as=80p ps=48u
M4146 DFFNEGX1_2/a_61_74# DFFNEGX1_2/a_34_4# vdd vdd pfet w=20 l=2
+  ad=59.999996p pd=46u as=0 ps=0
M4147 DFFNEGX1_2/a_34_4# DFFNEGX1_2/a_23_6# vdd vdd pfet w=20 l=2
+  ad=100p pd=50u as=0 ps=0
M4148 DFFNEGX1_2/a_34_4# DFFNEGX1_2/a_23_6# gnd Gnd nfet w=10 l=2
+  ad=50p pd=30u as=0 ps=0
M4149 vdd INVX2_2/A DFFNEGX1_2/a_76_84# vdd pfet w=10 l=2
+  ad=0 pd=0 as=29.999998p ps=26u
M4150 gnd INVX2_2/A DFFNEGX1_2/a_76_6# Gnd nfet w=10 l=2
+  ad=0 pd=0 as=0 ps=0
M4151 DFFNEGX1_2/a_61_6# DFFNEGX1_2/a_34_4# gnd Gnd nfet w=10 l=2
+  ad=0 pd=0 as=0 ps=0
M4152 DFFNEGX1_2/a_76_84# DFFNEGX1_2/a_2_6# DFFNEGX1_2/a_66_6# vdd pfet w=10 l=2
+  ad=0 pd=0 as=0.15n ps=56u
M4153 INVX2_2/A DFFNEGX1_2/a_66_6# vdd vdd pfet w=40 l=2
+  ad=0.2n pd=90u as=0 ps=0
M4154 vdd clka DFFNEGX1_2/a_2_6# vdd pfet w=40 l=2
+  ad=0 pd=0 as=0.2n ps=90u
M4155 DFFNEGX1_2/a_31_6# DFFNEGX1_2/a_2_6# DFFNEGX1_2/a_23_6# Gnd nfet w=10 l=2
+  ad=0 pd=0 as=0 ps=0
M4156 DFFNEGX1_2/a_66_6# clka DFFNEGX1_2/a_61_74# vdd pfet w=20 l=2
+  ad=0 pd=0 as=0 ps=0
M4157 DFFNEGX1_2/a_17_74# NOR2X1_19/Y vdd vdd pfet w=20 l=2
+  ad=0 pd=0 as=0 ps=0
M4158 DFFNEGX1_2/a_31_74# clka DFFNEGX1_2/a_23_6# vdd pfet w=20 l=2
+  ad=0 pd=0 as=0 ps=0
M4159 DFFNEGX1_2/a_17_6# NOR2X1_19/Y gnd Gnd nfet w=10 l=2
+  ad=0 pd=0 as=0 ps=0
M4160 gnd XOR2X1_7/A XOR2X1_7/a_2_6# Gnd nfet w=20 l=2
+  ad=0 pd=0 as=100p ps=50u
M4161 XOR2X1_7/Y XOR2X1_7/a_2_6# XOR2X1_7/a_18_6# Gnd nfet w=20 l=2
+  ad=0.2n pd=60u as=59.999996p ps=46u
M4162 XOR2X1_7/a_13_43# invader_2_coord_x[3] gnd Gnd nfet w=20 l=2
+  ad=100p pd=50u as=0 ps=0
M4163 XOR2X1_7/a_18_54# XOR2X1_7/a_13_43# vdd vdd pfet w=40 l=2
+  ad=0.12n pd=86u as=0 ps=0
M4164 XOR2X1_7/a_35_6# XOR2X1_7/A XOR2X1_7/Y Gnd nfet w=20 l=2
+  ad=59.999996p pd=46u as=0 ps=0
M4165 XOR2X1_7/a_18_6# XOR2X1_7/a_13_43# gnd Gnd nfet w=20 l=2
+  ad=0 pd=0 as=0 ps=0
M4166 vdd XOR2X1_7/A XOR2X1_7/a_2_6# vdd pfet w=40 l=2
+  ad=0 pd=0 as=0.2n ps=90u
M4167 vdd invader_2_coord_x[3] XOR2X1_7/a_35_54# vdd pfet w=40 l=2
+  ad=0 pd=0 as=0.12n ps=86u
M4168 XOR2X1_7/Y XOR2X1_7/A XOR2X1_7/a_18_54# vdd pfet w=40 l=2
+  ad=0.4n pd=100u as=0 ps=0
M4169 XOR2X1_7/a_35_54# XOR2X1_7/a_2_6# XOR2X1_7/Y vdd pfet w=40 l=2
+  ad=0 pd=0 as=0 ps=0
M4170 XOR2X1_7/a_13_43# invader_2_coord_x[3] vdd vdd pfet w=40 l=2
+  ad=0.2n pd=90u as=0 ps=0
M4171 gnd invader_2_coord_x[3] XOR2X1_7/a_35_6# Gnd nfet w=20 l=2
+  ad=0 pd=0 as=0 ps=0
M4172 INVX2_114/Y INVX2_114/A gnd Gnd nfet w=20 l=2
+  ad=100p pd=50u as=0 ps=0
M4173 INVX2_114/Y INVX2_114/A vdd vdd pfet w=40 l=2
+  ad=0.2n pd=90u as=0 ps=0
M4174 NOR2X1_56/B XOR2X1_19/Y gnd Gnd nfet w=20 l=2
+  ad=100p pd=50u as=0 ps=0
M4175 NOR2X1_56/B XOR2X1_19/Y vdd vdd pfet w=40 l=2
+  ad=0.2n pd=90u as=0 ps=0
M4176 NOR2X1_60/A INVX2_125/A gnd Gnd nfet w=20 l=2
+  ad=100p pd=50u as=0 ps=0
M4177 NOR2X1_60/A INVX2_125/A vdd vdd pfet w=40 l=2
+  ad=0.2n pd=90u as=0 ps=0
M4178 INVX2_147/Y INVX2_147/A gnd Gnd nfet w=20 l=2
+  ad=100p pd=50u as=0 ps=0
M4179 INVX2_147/Y INVX2_147/A vdd vdd pfet w=40 l=2
+  ad=0.2n pd=90u as=0 ps=0
M4180 INVX2_136/Y OR2X1_9/A gnd Gnd nfet w=20 l=2
+  ad=100p pd=50u as=0 ps=0
M4181 INVX2_136/Y OR2X1_9/A vdd vdd pfet w=40 l=2
+  ad=0.2n pd=90u as=0 ps=0
M4182 INVX2_158/Y INVX2_158/A gnd Gnd nfet w=20 l=2
+  ad=100p pd=50u as=0 ps=0
M4183 INVX2_158/Y INVX2_158/A vdd vdd pfet w=40 l=2
+  ad=0.2n pd=90u as=0 ps=0
M4184 INVX2_169/Y INVX2_169/A gnd Gnd nfet w=20 l=2
+  ad=100p pd=50u as=0 ps=0
M4185 INVX2_169/Y INVX2_169/A vdd vdd pfet w=40 l=2
+  ad=0.2n pd=90u as=0 ps=0
M4186 gnd invader_1_coord_x[1] XOR2X1_18/a_2_6# Gnd nfet w=20 l=2
+  ad=0 pd=0 as=100p ps=50u
M4187 XOR2X1_18/Y XOR2X1_18/a_2_6# XOR2X1_18/a_18_6# Gnd nfet w=20 l=2
+  ad=0.2n pd=60u as=59.999996p ps=46u
M4188 XOR2X1_18/a_13_43# player_coord_x[1] gnd Gnd nfet w=20 l=2
+  ad=100p pd=50u as=0 ps=0
M4189 XOR2X1_18/a_18_54# XOR2X1_18/a_13_43# vdd vdd pfet w=40 l=2
+  ad=0.12n pd=86u as=0 ps=0
M4190 XOR2X1_18/a_35_6# invader_1_coord_x[1] XOR2X1_18/Y Gnd nfet w=20 l=2
+  ad=59.999996p pd=46u as=0 ps=0
M4191 XOR2X1_18/a_18_6# XOR2X1_18/a_13_43# gnd Gnd nfet w=20 l=2
+  ad=0 pd=0 as=0 ps=0
M4192 vdd invader_1_coord_x[1] XOR2X1_18/a_2_6# vdd pfet w=40 l=2
+  ad=0 pd=0 as=0.2n ps=90u
M4193 vdd player_coord_x[1] XOR2X1_18/a_35_54# vdd pfet w=40 l=2
+  ad=0 pd=0 as=0.12n ps=86u
M4194 XOR2X1_18/Y invader_1_coord_x[1] XOR2X1_18/a_18_54# vdd pfet w=40 l=2
+  ad=0.4n pd=100u as=0 ps=0
M4195 XOR2X1_18/a_35_54# XOR2X1_18/a_2_6# XOR2X1_18/Y vdd pfet w=40 l=2
+  ad=0 pd=0 as=0 ps=0
M4196 XOR2X1_18/a_13_43# player_coord_x[1] vdd vdd pfet w=40 l=2
+  ad=0.2n pd=90u as=0 ps=0
M4197 gnd player_coord_x[1] XOR2X1_18/a_35_6# Gnd nfet w=20 l=2
+  ad=0 pd=0 as=0 ps=0
M4198 NAND3X1_8/Y NAND3X1_8/A vdd vdd pfet w=20 l=2
+  ad=0.22n pd=0.102m as=0 ps=0
M4199 NAND3X1_8/a_9_6# NAND3X1_8/A gnd Gnd nfet w=30 l=2
+  ad=90p pd=66u as=0 ps=0
M4200 NAND3X1_8/Y player_bullet_coord_y[2] vdd vdd pfet w=20 l=2
+  ad=0 pd=0 as=0 ps=0
M4201 NAND3X1_8/Y player_bullet_coord_y[2] NAND3X1_8/a_14_6# Gnd nfet w=30 l=2
+  ad=0.15n pd=70u as=90p ps=66u
M4202 vdd INVX2_75/Y NAND3X1_8/Y vdd pfet w=20 l=2
+  ad=0 pd=0 as=0 ps=0
M4203 NAND3X1_8/a_14_6# INVX2_75/Y NAND3X1_8/a_9_6# Gnd nfet w=30 l=2
+  ad=0 pd=0 as=0 ps=0
M4204 gnd INVX2_160/Y OAI21X1_104/a_2_6# Gnd nfet w=20 l=2
+  ad=0 pd=0 as=0.22n ps=0.102m
M4205 vdd AOI22X1_41/Y AOI22X1_40/B vdd pfet w=20 l=2
+  ad=0 pd=0 as=0.22n ps=92u
M4206 AOI22X1_40/B AOI22X1_41/Y OAI21X1_104/a_2_6# Gnd nfet w=20 l=2
+  ad=100p pd=50u as=0 ps=0
M4207 AOI22X1_40/B INVX2_120/Y OAI21X1_104/a_9_54# vdd pfet w=40 l=2
+  ad=0 pd=0 as=0.12n ps=86u
M4208 OAI21X1_104/a_9_54# INVX2_160/Y vdd vdd pfet w=40 l=2
+  ad=0 pd=0 as=0 ps=0
M4209 OAI21X1_104/a_2_6# INVX2_120/Y gnd Gnd nfet w=20 l=2
+  ad=0 pd=0 as=0 ps=0
M4210 gnd AOI21X1_28/Y OAI21X1_126/a_2_6# Gnd nfet w=20 l=2
+  ad=0 pd=0 as=0.22n ps=0.102m
M4211 vdd INVX2_166/A OAI21X1_126/Y vdd pfet w=20 l=2
+  ad=0 pd=0 as=0.22n ps=92u
M4212 OAI21X1_126/Y INVX2_166/A OAI21X1_126/a_2_6# Gnd nfet w=20 l=2
+  ad=100p pd=50u as=0 ps=0
M4213 OAI21X1_126/Y INVX2_153/Y OAI21X1_126/a_9_54# vdd pfet w=40 l=2
+  ad=0 pd=0 as=0.12n ps=86u
M4214 OAI21X1_126/a_9_54# AOI21X1_28/Y vdd vdd pfet w=40 l=2
+  ad=0 pd=0 as=0 ps=0
M4215 OAI21X1_126/a_2_6# INVX2_153/Y gnd Gnd nfet w=20 l=2
+  ad=0 pd=0 as=0 ps=0
M4216 gnd INVX2_118/Y OAI21X1_115/a_2_6# Gnd nfet w=20 l=2
+  ad=0 pd=0 as=0.22n ps=0.102m
M4217 vdd player_coord_x[3] OAI21X1_115/Y vdd pfet w=20 l=2
+  ad=0 pd=0 as=0.22n ps=92u
M4218 OAI21X1_115/Y player_coord_x[3] OAI21X1_115/a_2_6# Gnd nfet w=20 l=2
+  ad=100p pd=50u as=0 ps=0
M4219 OAI21X1_115/Y INVX2_6/Y OAI21X1_115/a_9_54# vdd pfet w=40 l=2
+  ad=0 pd=0 as=0.12n ps=86u
M4220 OAI21X1_115/a_9_54# INVX2_118/Y vdd vdd pfet w=40 l=2
+  ad=0 pd=0 as=0 ps=0
M4221 OAI21X1_115/a_2_6# INVX2_6/Y gnd Gnd nfet w=20 l=2
+  ad=0 pd=0 as=0 ps=0
M4222 gnd INVX2_33/Y OAI21X1_137/a_2_6# Gnd nfet w=20 l=2
+  ad=0 pd=0 as=0.22n ps=0.102m
M4223 vdd invader_1_display OAI22X1_9/D vdd pfet w=20 l=2
+  ad=0 pd=0 as=0.22n ps=92u
M4224 OAI22X1_9/D invader_1_display OAI21X1_137/a_2_6# Gnd nfet w=20 l=2
+  ad=100p pd=50u as=0 ps=0
M4225 OAI22X1_9/D NAND2X1_65/Y OAI21X1_137/a_9_54# vdd pfet w=40 l=2
+  ad=0 pd=0 as=0.12n ps=86u
M4226 OAI21X1_137/a_9_54# INVX2_33/Y vdd vdd pfet w=40 l=2
+  ad=0 pd=0 as=0 ps=0
M4227 OAI21X1_137/a_2_6# NAND2X1_65/Y gnd Gnd nfet w=20 l=2
+  ad=0 pd=0 as=0 ps=0
M4228 gnd OAI22X1_7/C OAI21X1_148/a_2_6# Gnd nfet w=20 l=2
+  ad=0 pd=0 as=0.22n ps=0.102m
M4229 vdd player_coord_x[1] OAI21X1_148/Y vdd pfet w=20 l=2
+  ad=0 pd=0 as=0.22n ps=92u
M4230 OAI21X1_148/Y player_coord_x[1] OAI21X1_148/a_2_6# Gnd nfet w=20 l=2
+  ad=100p pd=50u as=0 ps=0
M4231 OAI21X1_148/Y INVX2_102/A OAI21X1_148/a_9_54# vdd pfet w=40 l=2
+  ad=0 pd=0 as=0.12n ps=86u
M4232 OAI21X1_148/a_9_54# OAI22X1_7/C vdd vdd pfet w=40 l=2
+  ad=0 pd=0 as=0 ps=0
M4233 OAI21X1_148/a_2_6# INVX2_102/A gnd Gnd nfet w=20 l=2
+  ad=0 pd=0 as=0 ps=0
M4234 vdd BUFX2_4/A BUFX2_2/a_2_6# vdd pfet w=20 l=2
+  ad=0 pd=0 as=100p ps=50u
M4235 gnd BUFX2_4/A BUFX2_2/a_2_6# Gnd nfet w=10 l=2
+  ad=0 pd=0 as=50p ps=30u
M4236 BUFX2_2/Y BUFX2_2/a_2_6# vdd vdd pfet w=40 l=2
+  ad=0.2n pd=90u as=0 ps=0
M4237 BUFX2_2/Y BUFX2_2/a_2_6# gnd Gnd nfet w=20 l=2
+  ad=100p pd=50u as=0 ps=0
M4238 INVX2_2/Y INVX2_2/A gnd Gnd nfet w=20 l=2
+  ad=100p pd=50u as=0 ps=0
M4239 INVX2_2/Y INVX2_2/A vdd vdd pfet w=40 l=2
+  ad=0.2n pd=90u as=0 ps=0
M4240 AOI21X1_2/a_2_54# invader_2_coord_x[1] vdd vdd pfet w=40 l=2
+  ad=0.44n pd=0.182m as=0 ps=0
M4241 AOI21X1_2/a_12_6# invader_2_coord_x[0] gnd Gnd nfet w=20 l=2
+  ad=59.999996p pd=46u as=0 ps=0
M4242 gnd NOR2X1_6/Y INVX2_47/A Gnd nfet w=10 l=2
+  ad=0 pd=0 as=0.11n ps=52u
M4243 vdd invader_2_coord_x[0] AOI21X1_2/a_2_54# vdd pfet w=40 l=2
+  ad=0 pd=0 as=0 ps=0
M4244 INVX2_47/A NOR2X1_6/Y AOI21X1_2/a_2_54# vdd pfet w=40 l=2
+  ad=0.2n pd=90u as=0 ps=0
M4245 INVX2_47/A invader_2_coord_x[1] AOI21X1_2/a_12_6# Gnd nfet w=20 l=2
+  ad=0 pd=0 as=0 ps=0
M4246 NOR2X1_0/Y INVX2_2/Y gnd Gnd nfet w=10 l=2
+  ad=29.999998p pd=16u as=50p ps=30u
M4247 NOR2X1_0/Y OR2X1_15/A NOR2X1_0/a_9_54# vdd pfet w=40 l=2
+  ad=0.2n pd=90u as=59.999996p ps=43u
M4248 NOR2X1_0/a_9_54# INVX2_2/Y vdd vdd pfet w=40 l=2
+  ad=59.999996p pd=43u as=0.2n ps=90u
M4249 gnd OR2X1_15/A NOR2X1_0/Y Gnd nfet w=10 l=2
+  ad=50p pd=30u as=29.999998p ps=16u
M4250 AOI21X1_10/a_2_54# invader_1_coord_x[1] vdd vdd pfet w=40 l=2
+  ad=0.44n pd=0.182m as=0 ps=0
M4251 AOI21X1_10/a_12_6# invader_1_coord_x[0] gnd Gnd nfet w=20 l=2
+  ad=59.999996p pd=46u as=0 ps=0
M4252 gnd NOR2X1_10/Y INVX2_63/A Gnd nfet w=10 l=2
+  ad=0 pd=0 as=0.11n ps=52u
M4253 vdd invader_1_coord_x[0] AOI21X1_10/a_2_54# vdd pfet w=40 l=2
+  ad=0 pd=0 as=0 ps=0
M4254 INVX2_63/A NOR2X1_10/Y AOI21X1_10/a_2_54# vdd pfet w=40 l=2
+  ad=0.2n pd=90u as=0 ps=0
M4255 INVX2_63/A invader_1_coord_x[1] AOI21X1_10/a_12_6# Gnd nfet w=20 l=2
+  ad=0 pd=0 as=0 ps=0
M4256 AOI21X1_21/a_2_54# NOR2X1_2/Y vdd vdd pfet w=40 l=2
+  ad=0.44n pd=0.182m as=0 ps=0
M4257 AOI21X1_21/a_12_6# invader_bullet_coord_y[3] gnd Gnd nfet w=20 l=2
+  ad=59.999996p pd=46u as=0 ps=0
M4258 gnd OR2X1_15/A NAND2X1_0/B Gnd nfet w=10 l=2
+  ad=0 pd=0 as=0.11n ps=52u
M4259 vdd invader_bullet_coord_y[3] AOI21X1_21/a_2_54# vdd pfet w=40 l=2
+  ad=0 pd=0 as=0 ps=0
M4260 NAND2X1_0/B OR2X1_15/A AOI21X1_21/a_2_54# vdd pfet w=40 l=2
+  ad=0.2n pd=90u as=0 ps=0
M4261 NAND2X1_0/B NOR2X1_2/Y AOI21X1_21/a_12_6# Gnd nfet w=20 l=2
+  ad=0 pd=0 as=0 ps=0
M4262 vdd invader_2_coord_y[2] HAX1_13/a_2_74# vdd pfet w=20 l=2
+  ad=0 pd=0 as=0.2n ps=100u
M4263 HAX1_13/a_41_74# HAX1_13/a_2_74# vdd vdd pfet w=20 l=2
+  ad=0.22n pd=92u as=0 ps=0
M4264 HAX1_13/a_9_6# invader_2_coord_y[2] gnd Gnd nfet w=20 l=2
+  ad=59.999996p pd=46u as=0 ps=0
M4265 HAX1_13/a_41_74# HAX1_13/B HAX1_13/a_38_6# Gnd nfet w=20 l=2
+  ad=0.12n pd=52u as=0.216n ps=0.102m
M4266 vdd invader_2_coord_y[2] HAX1_13/a_49_54# vdd pfet w=40 l=2
+  ad=0 pd=0 as=0.12n ps=86u
M4267 vdd HAX1_13/a_2_74# HAX1_12/B vdd pfet w=20 l=2
+  ad=0 pd=0 as=100p ps=50u
M4268 HAX1_13/a_38_6# HAX1_13/a_2_74# gnd Gnd nfet w=20 l=2
+  ad=0 pd=0 as=0 ps=0
M4269 HAX1_13/YS HAX1_13/a_41_74# vdd vdd pfet w=20 l=2
+  ad=100p pd=50u as=0 ps=0
M4270 HAX1_13/a_38_6# invader_2_coord_y[2] HAX1_13/a_41_74# Gnd nfet w=20 l=2
+  ad=0 pd=0 as=0 ps=0
M4271 HAX1_13/YS HAX1_13/a_41_74# gnd Gnd nfet w=10 l=2
+  ad=50p pd=30u as=0 ps=0
M4272 HAX1_13/a_2_74# HAX1_13/B vdd vdd pfet w=20 l=2
+  ad=0 pd=0 as=0 ps=0
M4273 HAX1_13/a_2_74# HAX1_13/B HAX1_13/a_9_6# Gnd nfet w=20 l=2
+  ad=100p pd=50u as=0 ps=0
M4274 HAX1_13/a_49_54# HAX1_13/B HAX1_13/a_41_74# vdd pfet w=40 l=2
+  ad=0 pd=0 as=0 ps=0
M4275 gnd HAX1_13/a_2_74# HAX1_12/B Gnd nfet w=10 l=2
+  ad=0 pd=0 as=50p ps=30u
M4276 gnd player_bullet_coord_x[2] OAI21X1_5/a_2_6# Gnd nfet w=20 l=2
+  ad=0 pd=0 as=0.22n ps=0.102m
M4277 vdd OAI21X1_5/C OAI21X1_5/Y vdd pfet w=20 l=2
+  ad=0 pd=0 as=0.22n ps=92u
M4278 OAI21X1_5/Y OAI21X1_5/C OAI21X1_5/a_2_6# Gnd nfet w=20 l=2
+  ad=100p pd=50u as=0 ps=0
M4279 OAI21X1_5/Y INVX2_46/Y OAI21X1_5/a_9_54# vdd pfet w=40 l=2
+  ad=0 pd=0 as=0.12n ps=86u
M4280 OAI21X1_5/a_9_54# player_bullet_coord_x[2] vdd vdd pfet w=40 l=2
+  ad=0 pd=0 as=0 ps=0
M4281 OAI21X1_5/a_2_6# INVX2_46/Y gnd Gnd nfet w=20 l=2
+  ad=0 pd=0 as=0 ps=0
M4282 DFFNEGX1_3/a_76_6# BUFX2_7/Y DFFNEGX1_3/a_66_6# Gnd nfet w=10 l=2
+  ad=29.999998p pd=26u as=80p ps=36u
M4283 gnd BUFX2_7/Y DFFNEGX1_3/a_2_6# Gnd nfet w=20 l=2
+  ad=0 pd=0 as=100p ps=50u
M4284 DFFNEGX1_3/a_66_6# DFFNEGX1_3/a_2_6# DFFNEGX1_3/a_61_6# Gnd nfet w=10 l=2
+  ad=0 pd=0 as=29.999998p ps=26u
M4285 invader_bullet_coord_x[1] DFFNEGX1_3/a_66_6# gnd Gnd nfet w=20 l=2
+  ad=100p pd=50u as=0 ps=0
M4286 DFFNEGX1_3/a_23_6# BUFX2_7/Y DFFNEGX1_3/a_17_6# Gnd nfet w=10 l=2
+  ad=59.999996p pd=32u as=40p ps=28u
M4287 DFFNEGX1_3/a_23_6# DFFNEGX1_3/a_2_6# DFFNEGX1_3/a_17_74# vdd pfet w=20 l=2
+  ad=0.12n pd=52u as=80p ps=48u
M4288 gnd DFFNEGX1_3/a_34_4# DFFNEGX1_3/a_31_6# Gnd nfet w=10 l=2
+  ad=0 pd=0 as=29.999998p ps=26u
M4289 vdd DFFNEGX1_3/a_34_4# DFFNEGX1_3/a_31_74# vdd pfet w=20 l=2
+  ad=0 pd=0 as=80p ps=48u
M4290 DFFNEGX1_3/a_61_74# DFFNEGX1_3/a_34_4# vdd vdd pfet w=20 l=2
+  ad=59.999996p pd=46u as=0 ps=0
M4291 DFFNEGX1_3/a_34_4# DFFNEGX1_3/a_23_6# vdd vdd pfet w=20 l=2
+  ad=100p pd=50u as=0 ps=0
M4292 DFFNEGX1_3/a_34_4# DFFNEGX1_3/a_23_6# gnd Gnd nfet w=10 l=2
+  ad=50p pd=30u as=0 ps=0
M4293 vdd invader_bullet_coord_x[1] DFFNEGX1_3/a_76_84# vdd pfet w=10 l=2
+  ad=0 pd=0 as=29.999998p ps=26u
M4294 gnd invader_bullet_coord_x[1] DFFNEGX1_3/a_76_6# Gnd nfet w=10 l=2
+  ad=0 pd=0 as=0 ps=0
M4295 DFFNEGX1_3/a_61_6# DFFNEGX1_3/a_34_4# gnd Gnd nfet w=10 l=2
+  ad=0 pd=0 as=0 ps=0
M4296 DFFNEGX1_3/a_76_84# DFFNEGX1_3/a_2_6# DFFNEGX1_3/a_66_6# vdd pfet w=10 l=2
+  ad=0 pd=0 as=0.15n ps=56u
M4297 invader_bullet_coord_x[1] DFFNEGX1_3/a_66_6# vdd vdd pfet w=40 l=2
+  ad=0.2n pd=90u as=0 ps=0
M4298 vdd BUFX2_7/Y DFFNEGX1_3/a_2_6# vdd pfet w=40 l=2
+  ad=0 pd=0 as=0.2n ps=90u
M4299 DFFNEGX1_3/a_31_6# DFFNEGX1_3/a_2_6# DFFNEGX1_3/a_23_6# Gnd nfet w=10 l=2
+  ad=0 pd=0 as=0 ps=0
M4300 DFFNEGX1_3/a_66_6# BUFX2_7/Y DFFNEGX1_3/a_61_74# vdd pfet w=20 l=2
+  ad=0 pd=0 as=0 ps=0
M4301 DFFNEGX1_3/a_17_74# OAI21X1_40/Y vdd vdd pfet w=20 l=2
+  ad=0 pd=0 as=0 ps=0
M4302 DFFNEGX1_3/a_31_74# BUFX2_7/Y DFFNEGX1_3/a_23_6# vdd pfet w=20 l=2
+  ad=0 pd=0 as=0 ps=0
M4303 DFFNEGX1_3/a_17_6# OAI21X1_40/Y gnd Gnd nfet w=10 l=2
+  ad=0 pd=0 as=0 ps=0
M4304 gnd invader_2_coord_x[1] XOR2X1_8/a_2_6# Gnd nfet w=20 l=2
+  ad=0 pd=0 as=100p ps=50u
M4305 XOR2X1_8/Y XOR2X1_8/a_2_6# XOR2X1_8/a_18_6# Gnd nfet w=20 l=2
+  ad=0.2n pd=60u as=59.999996p ps=46u
M4306 XOR2X1_8/a_13_43# invader_2_coord_x[2] gnd Gnd nfet w=20 l=2
+  ad=100p pd=50u as=0 ps=0
M4307 XOR2X1_8/a_18_54# XOR2X1_8/a_13_43# vdd vdd pfet w=40 l=2
+  ad=0.12n pd=86u as=0 ps=0
M4308 XOR2X1_8/a_35_6# invader_2_coord_x[1] XOR2X1_8/Y Gnd nfet w=20 l=2
+  ad=59.999996p pd=46u as=0 ps=0
M4309 XOR2X1_8/a_18_6# XOR2X1_8/a_13_43# gnd Gnd nfet w=20 l=2
+  ad=0 pd=0 as=0 ps=0
M4310 vdd invader_2_coord_x[1] XOR2X1_8/a_2_6# vdd pfet w=40 l=2
+  ad=0 pd=0 as=0.2n ps=90u
M4311 vdd invader_2_coord_x[2] XOR2X1_8/a_35_54# vdd pfet w=40 l=2
+  ad=0 pd=0 as=0.12n ps=86u
M4312 XOR2X1_8/Y invader_2_coord_x[1] XOR2X1_8/a_18_54# vdd pfet w=40 l=2
+  ad=0.4n pd=100u as=0 ps=0
M4313 XOR2X1_8/a_35_54# XOR2X1_8/a_2_6# XOR2X1_8/Y vdd pfet w=40 l=2
+  ad=0 pd=0 as=0 ps=0
M4314 XOR2X1_8/a_13_43# invader_2_coord_x[2] vdd vdd pfet w=40 l=2
+  ad=0.2n pd=90u as=0 ps=0
M4315 gnd invader_2_coord_x[2] XOR2X1_8/a_35_6# Gnd nfet w=20 l=2
+  ad=0 pd=0 as=0 ps=0
M4316 NOR2X1_57/B XOR2X1_20/Y gnd Gnd nfet w=20 l=2
+  ad=100p pd=50u as=0 ps=0
M4317 NOR2X1_57/B XOR2X1_20/Y vdd vdd pfet w=40 l=2
+  ad=0.2n pd=90u as=0 ps=0
M4318 INVX2_126/Y INVX2_126/A gnd Gnd nfet w=20 l=2
+  ad=100p pd=50u as=0 ps=0
M4319 INVX2_126/Y INVX2_126/A vdd vdd pfet w=40 l=2
+  ad=0.2n pd=90u as=0 ps=0
M4320 INVX2_115/Y INVX2_115/A gnd Gnd nfet w=20 l=2
+  ad=100p pd=50u as=0 ps=0
M4321 INVX2_115/Y INVX2_115/A vdd vdd pfet w=40 l=2
+  ad=0.2n pd=90u as=0 ps=0
M4322 OR2X1_8/B NOR2X1_31/Y gnd Gnd nfet w=20 l=2
+  ad=100p pd=50u as=0 ps=0
M4323 OR2X1_8/B NOR2X1_31/Y vdd vdd pfet w=40 l=2
+  ad=0.2n pd=90u as=0 ps=0
M4324 NOR2X1_45/A INVX2_159/A gnd Gnd nfet w=20 l=2
+  ad=100p pd=50u as=0 ps=0
M4325 NOR2X1_45/A INVX2_159/A vdd vdd pfet w=40 l=2
+  ad=0.2n pd=90u as=0 ps=0
M4326 INVX2_148/Y INVX2_148/A gnd Gnd nfet w=20 l=2
+  ad=100p pd=50u as=0 ps=0
M4327 INVX2_148/Y INVX2_148/A vdd vdd pfet w=40 l=2
+  ad=0.2n pd=90u as=0 ps=0
M4328 gnd invader_2_coord_x[3] XOR2X1_19/a_2_6# Gnd nfet w=20 l=2
+  ad=0 pd=0 as=100p ps=50u
M4329 XOR2X1_19/Y XOR2X1_19/a_2_6# XOR2X1_19/a_18_6# Gnd nfet w=20 l=2
+  ad=0.2n pd=60u as=59.999996p ps=46u
M4330 XOR2X1_19/a_13_43# player_coord_x[3] gnd Gnd nfet w=20 l=2
+  ad=100p pd=50u as=0 ps=0
M4331 XOR2X1_19/a_18_54# XOR2X1_19/a_13_43# vdd vdd pfet w=40 l=2
+  ad=0.12n pd=86u as=0 ps=0
M4332 XOR2X1_19/a_35_6# invader_2_coord_x[3] XOR2X1_19/Y Gnd nfet w=20 l=2
+  ad=59.999996p pd=46u as=0 ps=0
M4333 XOR2X1_19/a_18_6# XOR2X1_19/a_13_43# gnd Gnd nfet w=20 l=2
+  ad=0 pd=0 as=0 ps=0
M4334 vdd invader_2_coord_x[3] XOR2X1_19/a_2_6# vdd pfet w=40 l=2
+  ad=0 pd=0 as=0.2n ps=90u
M4335 vdd player_coord_x[3] XOR2X1_19/a_35_54# vdd pfet w=40 l=2
+  ad=0 pd=0 as=0.12n ps=86u
M4336 XOR2X1_19/Y invader_2_coord_x[3] XOR2X1_19/a_18_54# vdd pfet w=40 l=2
+  ad=0.4n pd=100u as=0 ps=0
M4337 XOR2X1_19/a_35_54# XOR2X1_19/a_2_6# XOR2X1_19/Y vdd pfet w=40 l=2
+  ad=0 pd=0 as=0 ps=0
M4338 XOR2X1_19/a_13_43# player_coord_x[3] vdd vdd pfet w=40 l=2
+  ad=0.2n pd=90u as=0 ps=0
M4339 gnd player_coord_x[3] XOR2X1_19/a_35_6# Gnd nfet w=20 l=2
+  ad=0 pd=0 as=0 ps=0
M4340 NAND3X1_9/Y XOR2X1_6/Y vdd vdd pfet w=20 l=2
+  ad=0.22n pd=0.102m as=0 ps=0
M4341 NAND3X1_9/a_9_6# XOR2X1_6/Y gnd Gnd nfet w=30 l=2
+  ad=90p pd=66u as=0 ps=0
M4342 NAND3X1_9/Y XOR2X1_5/Y vdd vdd pfet w=20 l=2
+  ad=0 pd=0 as=0 ps=0
M4343 NAND3X1_9/Y XOR2X1_5/Y NAND3X1_9/a_14_6# Gnd nfet w=30 l=2
+  ad=0.15n pd=70u as=90p ps=66u
M4344 vdd OAI22X1_7/C NAND3X1_9/Y vdd pfet w=20 l=2
+  ad=0 pd=0 as=0 ps=0
M4345 NAND3X1_9/a_14_6# OAI22X1_7/C NAND3X1_9/a_9_6# Gnd nfet w=30 l=2
+  ad=0 pd=0 as=0 ps=0
M4346 gnd INVX2_161/Y OAI21X1_105/a_2_6# Gnd nfet w=20 l=2
+  ad=0 pd=0 as=0.22n ps=0.102m
M4347 vdd OAI21X1_106/Y INVX2_162/A vdd pfet w=20 l=2
+  ad=0 pd=0 as=0.22n ps=92u
M4348 INVX2_162/A OAI21X1_106/Y OAI21X1_105/a_2_6# Gnd nfet w=20 l=2
+  ad=100p pd=50u as=0 ps=0
M4349 INVX2_162/A NOR2X1_45/Y OAI21X1_105/a_9_54# vdd pfet w=40 l=2
+  ad=0 pd=0 as=0.12n ps=86u
M4350 OAI21X1_105/a_9_54# INVX2_161/Y vdd vdd pfet w=40 l=2
+  ad=0 pd=0 as=0 ps=0
M4351 OAI21X1_105/a_2_6# NOR2X1_45/Y gnd Gnd nfet w=20 l=2
+  ad=0 pd=0 as=0 ps=0
M4352 gnd INVX2_128/A OAI21X1_127/a_2_6# Gnd nfet w=20 l=2
+  ad=0 pd=0 as=0.22n ps=0.102m
M4353 vdd INVX2_165/Y OR2X1_18/A vdd pfet w=20 l=2
+  ad=0 pd=0 as=0.22n ps=92u
M4354 OR2X1_18/A INVX2_165/Y OAI21X1_127/a_2_6# Gnd nfet w=20 l=2
+  ad=100p pd=50u as=0 ps=0
M4355 OR2X1_18/A INVX2_125/A OAI21X1_127/a_9_54# vdd pfet w=40 l=2
+  ad=0 pd=0 as=0.12n ps=86u
M4356 OAI21X1_127/a_9_54# INVX2_128/A vdd vdd pfet w=40 l=2
+  ad=0 pd=0 as=0 ps=0
M4357 OAI21X1_127/a_2_6# INVX2_125/A gnd Gnd nfet w=20 l=2
+  ad=0 pd=0 as=0 ps=0
M4358 gnd player_coord_x[2] OAI21X1_116/a_2_6# Gnd nfet w=20 l=2
+  ad=0 pd=0 as=0.22n ps=0.102m
M4359 vdd NAND2X1_57/Y INVX2_118/A vdd pfet w=20 l=2
+  ad=0 pd=0 as=0.22n ps=92u
M4360 INVX2_118/A NAND2X1_57/Y OAI21X1_116/a_2_6# Gnd nfet w=20 l=2
+  ad=100p pd=50u as=0 ps=0
M4361 INVX2_118/A INVX2_4/Y OAI21X1_116/a_9_54# vdd pfet w=40 l=2
+  ad=0 pd=0 as=0.12n ps=86u
M4362 OAI21X1_116/a_9_54# player_coord_x[2] vdd vdd pfet w=40 l=2
+  ad=0 pd=0 as=0 ps=0
M4363 OAI21X1_116/a_2_6# INVX2_4/Y gnd Gnd nfet w=20 l=2
+  ad=0 pd=0 as=0 ps=0
M4364 gnd player_coord_x[2] OAI21X1_138/a_2_6# Gnd nfet w=20 l=2
+  ad=0 pd=0 as=0.22n ps=0.102m
M4365 vdd XNOR2X1_5/B AOI21X1_30/B vdd pfet w=20 l=2
+  ad=0 pd=0 as=0.22n ps=92u
M4366 AOI21X1_30/B XNOR2X1_5/B OAI21X1_138/a_2_6# Gnd nfet w=20 l=2
+  ad=100p pd=50u as=0 ps=0
M4367 AOI21X1_30/B INVX2_44/Y OAI21X1_138/a_9_54# vdd pfet w=40 l=2
+  ad=0 pd=0 as=0.12n ps=86u
M4368 OAI21X1_138/a_9_54# player_coord_x[2] vdd vdd pfet w=40 l=2
+  ad=0 pd=0 as=0 ps=0
M4369 OAI21X1_138/a_2_6# INVX2_44/Y gnd Gnd nfet w=20 l=2
+  ad=0 pd=0 as=0 ps=0
M4370 gnd invader_1_coord_x[3] OAI21X1_149/a_2_6# Gnd nfet w=20 l=2
+  ad=0 pd=0 as=0.22n ps=0.102m
M4371 vdd NAND2X1_78/Y INVX2_110/A vdd pfet w=20 l=2
+  ad=0 pd=0 as=0.22n ps=92u
M4372 INVX2_110/A NAND2X1_78/Y OAI21X1_149/a_2_6# Gnd nfet w=20 l=2
+  ad=100p pd=50u as=0 ps=0
M4373 INVX2_110/A INVX2_182/Y OAI21X1_149/a_9_54# vdd pfet w=40 l=2
+  ad=0 pd=0 as=0.12n ps=86u
M4374 OAI21X1_149/a_9_54# invader_1_coord_x[3] vdd vdd pfet w=40 l=2
+  ad=0 pd=0 as=0 ps=0
M4375 OAI21X1_149/a_2_6# INVX2_182/Y gnd Gnd nfet w=20 l=2
+  ad=0 pd=0 as=0 ps=0
M4376 vdd BUFX2_4/A BUFX2_3/a_2_6# vdd pfet w=20 l=2
+  ad=0 pd=0 as=100p ps=50u
M4377 gnd BUFX2_4/A BUFX2_3/a_2_6# Gnd nfet w=10 l=2
+  ad=0 pd=0 as=50p ps=30u
M4378 BUFX2_3/Y BUFX2_3/a_2_6# vdd vdd pfet w=40 l=2
+  ad=0.2n pd=90u as=0 ps=0
M4379 BUFX2_3/Y BUFX2_3/a_2_6# gnd Gnd nfet w=20 l=2
+  ad=100p pd=50u as=0 ps=0
M4380 INVX2_3/Y invader_bullet_coord_x[1] gnd Gnd nfet w=20 l=2
+  ad=100p pd=50u as=0 ps=0
M4381 INVX2_3/Y invader_bullet_coord_x[1] vdd vdd pfet w=40 l=2
+  ad=0.2n pd=90u as=0 ps=0
M4382 AOI21X1_3/a_2_54# OAI21X1_4/B vdd vdd pfet w=40 l=2
+  ad=0.44n pd=0.182m as=0 ps=0
M4383 AOI21X1_3/a_12_6# INVX2_45/A gnd Gnd nfet w=20 l=2
+  ad=59.999996p pd=46u as=0 ps=0
M4384 gnd AOI22X1_1/Y AOI22X1_0/A Gnd nfet w=10 l=2
+  ad=0 pd=0 as=0.11n ps=52u
M4385 vdd INVX2_45/A AOI21X1_3/a_2_54# vdd pfet w=40 l=2
+  ad=0 pd=0 as=0 ps=0
M4386 AOI22X1_0/A AOI22X1_1/Y AOI21X1_3/a_2_54# vdd pfet w=40 l=2
+  ad=0.2n pd=90u as=0 ps=0
M4387 AOI22X1_0/A OAI21X1_4/B AOI21X1_3/a_12_6# Gnd nfet w=20 l=2
+  ad=0 pd=0 as=0 ps=0
M4388 NOR2X1_1/Y NOR2X1_1/A gnd Gnd nfet w=10 l=2
+  ad=59.999996p pd=32u as=0 ps=0
M4389 NOR2X1_1/Y OR2X1_15/A NOR2X1_1/a_9_54# vdd pfet w=40 l=2
+  ad=0.2n pd=90u as=0.12n ps=86u
M4390 NOR2X1_1/a_9_54# NOR2X1_1/A vdd vdd pfet w=40 l=2
+  ad=0 pd=0 as=0 ps=0
M4391 gnd OR2X1_15/A NOR2X1_1/Y Gnd nfet w=10 l=2
+  ad=0 pd=0 as=0 ps=0
M4392 AOI21X1_22/a_2_54# INVX2_2/Y vdd vdd pfet w=40 l=2
+  ad=0.44n pd=0.182m as=0 ps=0
M4393 AOI21X1_22/a_12_6# INVX2_114/Y gnd Gnd nfet w=20 l=2
+  ad=59.999996p pd=46u as=0 ps=0
M4394 gnd OR2X1_15/A OAI21X1_46/C Gnd nfet w=10 l=2
+  ad=0 pd=0 as=0.11n ps=52u
M4395 vdd INVX2_114/Y AOI21X1_22/a_2_54# vdd pfet w=40 l=2
+  ad=0 pd=0 as=0 ps=0
M4396 OAI21X1_46/C OR2X1_15/A AOI21X1_22/a_2_54# vdd pfet w=40 l=2
+  ad=0.2n pd=90u as=0 ps=0
M4397 OAI21X1_46/C INVX2_2/Y AOI21X1_22/a_12_6# Gnd nfet w=20 l=2
+  ad=0 pd=0 as=0 ps=0
M4398 vdd invader_2_coord_y[1] HAX1_14/a_2_74# vdd pfet w=20 l=2
+  ad=0 pd=0 as=0.2n ps=100u
M4399 HAX1_14/a_41_74# HAX1_14/a_2_74# vdd vdd pfet w=20 l=2
+  ad=0.22n pd=92u as=0 ps=0
M4400 HAX1_14/a_9_6# invader_2_coord_y[1] gnd Gnd nfet w=20 l=2
+  ad=59.999996p pd=46u as=0 ps=0
M4401 HAX1_14/a_41_74# invader_2_coord_y[0] HAX1_14/a_38_6# Gnd nfet w=20 l=2
+  ad=0.12n pd=52u as=0.216n ps=0.102m
M4402 vdd invader_2_coord_y[1] HAX1_14/a_49_54# vdd pfet w=40 l=2
+  ad=0 pd=0 as=0.12n ps=86u
M4403 vdd HAX1_14/a_2_74# HAX1_13/B vdd pfet w=20 l=2
+  ad=0 pd=0 as=100p ps=50u
M4404 HAX1_14/a_38_6# HAX1_14/a_2_74# gnd Gnd nfet w=20 l=2
+  ad=0 pd=0 as=0 ps=0
M4405 INVX2_34/A HAX1_14/a_41_74# vdd vdd pfet w=20 l=2
+  ad=100p pd=50u as=0 ps=0
M4406 HAX1_14/a_38_6# invader_2_coord_y[1] HAX1_14/a_41_74# Gnd nfet w=20 l=2
+  ad=0 pd=0 as=0 ps=0
M4407 INVX2_34/A HAX1_14/a_41_74# gnd Gnd nfet w=10 l=2
+  ad=50p pd=30u as=0 ps=0
M4408 HAX1_14/a_2_74# invader_2_coord_y[0] vdd vdd pfet w=20 l=2
+  ad=0 pd=0 as=0 ps=0
M4409 HAX1_14/a_2_74# invader_2_coord_y[0] HAX1_14/a_9_6# Gnd nfet w=20 l=2
+  ad=100p pd=50u as=0 ps=0
M4410 HAX1_14/a_49_54# invader_2_coord_y[0] HAX1_14/a_41_74# vdd pfet w=40 l=2
+  ad=0 pd=0 as=0 ps=0
M4411 gnd HAX1_14/a_2_74# HAX1_13/B Gnd nfet w=10 l=2
+  ad=0 pd=0 as=50p ps=30u
M4412 AOI21X1_11/a_2_54# OAI21X1_4/B vdd vdd pfet w=40 l=2
+  ad=0.44n pd=0.182m as=0 ps=0
M4413 AOI21X1_11/a_12_6# INVX2_62/A gnd Gnd nfet w=20 l=2
+  ad=59.999996p pd=46u as=0 ps=0
M4414 gnd AOI22X1_5/Y AOI22X1_4/A Gnd nfet w=10 l=2
+  ad=0 pd=0 as=0.11n ps=52u
M4415 vdd INVX2_62/A AOI21X1_11/a_2_54# vdd pfet w=40 l=2
+  ad=0 pd=0 as=0 ps=0
M4416 AOI22X1_4/A AOI22X1_5/Y AOI21X1_11/a_2_54# vdd pfet w=40 l=2
+  ad=0.2n pd=90u as=0 ps=0
M4417 AOI22X1_4/A OAI21X1_4/B AOI21X1_11/a_12_6# Gnd nfet w=20 l=2
+  ad=0 pd=0 as=0 ps=0
M4418 gnd INVX2_50/Y OAI21X1_6/a_2_6# Gnd nfet w=20 l=2
+  ad=0 pd=0 as=0.22n ps=0.102m
M4419 vdd OAI21X1_6/C INVX2_51/A vdd pfet w=20 l=2
+  ad=0 pd=0 as=0.22n ps=92u
M4420 INVX2_51/A OAI21X1_6/C OAI21X1_6/a_2_6# Gnd nfet w=20 l=2
+  ad=100p pd=50u as=0 ps=0
M4421 INVX2_51/A INVX2_18/Y OAI21X1_6/a_9_54# vdd pfet w=40 l=2
+  ad=0 pd=0 as=0.12n ps=86u
M4422 OAI21X1_6/a_9_54# INVX2_50/Y vdd vdd pfet w=40 l=2
+  ad=0 pd=0 as=0 ps=0
M4423 OAI21X1_6/a_2_6# INVX2_18/Y gnd Gnd nfet w=20 l=2
+  ad=0 pd=0 as=0 ps=0
M4424 DFFNEGX1_4/a_76_6# BUFX2_7/Y DFFNEGX1_4/a_66_6# Gnd nfet w=10 l=2
+  ad=29.999998p pd=26u as=80p ps=36u
M4425 gnd BUFX2_7/Y DFFNEGX1_4/a_2_6# Gnd nfet w=20 l=2
+  ad=0 pd=0 as=100p ps=50u
M4426 DFFNEGX1_4/a_66_6# DFFNEGX1_4/a_2_6# DFFNEGX1_4/a_61_6# Gnd nfet w=10 l=2
+  ad=0 pd=0 as=29.999998p ps=26u
M4427 invader_bullet_coord_x[2] DFFNEGX1_4/a_66_6# gnd Gnd nfet w=20 l=2
+  ad=100p pd=50u as=0 ps=0
M4428 DFFNEGX1_4/a_23_6# BUFX2_7/Y DFFNEGX1_4/a_17_6# Gnd nfet w=10 l=2
+  ad=59.999996p pd=32u as=40p ps=28u
M4429 DFFNEGX1_4/a_23_6# DFFNEGX1_4/a_2_6# DFFNEGX1_4/a_17_74# vdd pfet w=20 l=2
+  ad=0.12n pd=52u as=80p ps=48u
M4430 gnd DFFNEGX1_4/a_34_4# DFFNEGX1_4/a_31_6# Gnd nfet w=10 l=2
+  ad=0 pd=0 as=29.999998p ps=26u
M4431 vdd DFFNEGX1_4/a_34_4# DFFNEGX1_4/a_31_74# vdd pfet w=20 l=2
+  ad=0 pd=0 as=80p ps=48u
M4432 DFFNEGX1_4/a_61_74# DFFNEGX1_4/a_34_4# vdd vdd pfet w=20 l=2
+  ad=59.999996p pd=46u as=0 ps=0
M4433 DFFNEGX1_4/a_34_4# DFFNEGX1_4/a_23_6# vdd vdd pfet w=20 l=2
+  ad=100p pd=50u as=0 ps=0
M4434 DFFNEGX1_4/a_34_4# DFFNEGX1_4/a_23_6# gnd Gnd nfet w=10 l=2
+  ad=50p pd=30u as=0 ps=0
M4435 vdd invader_bullet_coord_x[2] DFFNEGX1_4/a_76_84# vdd pfet w=10 l=2
+  ad=0 pd=0 as=29.999998p ps=26u
M4436 gnd invader_bullet_coord_x[2] DFFNEGX1_4/a_76_6# Gnd nfet w=10 l=2
+  ad=0 pd=0 as=0 ps=0
M4437 DFFNEGX1_4/a_61_6# DFFNEGX1_4/a_34_4# gnd Gnd nfet w=10 l=2
+  ad=0 pd=0 as=0 ps=0
M4438 DFFNEGX1_4/a_76_84# DFFNEGX1_4/a_2_6# DFFNEGX1_4/a_66_6# vdd pfet w=10 l=2
+  ad=0 pd=0 as=0.15n ps=56u
M4439 invader_bullet_coord_x[2] DFFNEGX1_4/a_66_6# vdd vdd pfet w=40 l=2
+  ad=0.2n pd=90u as=0 ps=0
M4440 vdd BUFX2_7/Y DFFNEGX1_4/a_2_6# vdd pfet w=40 l=2
+  ad=0 pd=0 as=0.2n ps=90u
M4441 DFFNEGX1_4/a_31_6# DFFNEGX1_4/a_2_6# DFFNEGX1_4/a_23_6# Gnd nfet w=10 l=2
+  ad=0 pd=0 as=0 ps=0
M4442 DFFNEGX1_4/a_66_6# BUFX2_7/Y DFFNEGX1_4/a_61_74# vdd pfet w=20 l=2
+  ad=0 pd=0 as=0 ps=0
M4443 DFFNEGX1_4/a_17_74# OAI21X1_41/Y vdd vdd pfet w=20 l=2
+  ad=0 pd=0 as=0 ps=0
M4444 DFFNEGX1_4/a_31_74# BUFX2_7/Y DFFNEGX1_4/a_23_6# vdd pfet w=20 l=2
+  ad=0 pd=0 as=0 ps=0
M4445 DFFNEGX1_4/a_17_6# OAI21X1_41/Y gnd Gnd nfet w=10 l=2
+  ad=0 pd=0 as=0 ps=0
M4446 gnd shield_coord_y[0] XOR2X1_9/a_2_6# Gnd nfet w=20 l=2
+  ad=0 pd=0 as=100p ps=50u
M4447 XOR2X1_9/Y XOR2X1_9/a_2_6# XOR2X1_9/a_18_6# Gnd nfet w=20 l=2
+  ad=0.2n pd=60u as=59.999996p ps=46u
M4448 XOR2X1_9/a_13_43# player_bullet_coord_y[0] gnd Gnd nfet w=20 l=2
+  ad=100p pd=50u as=0 ps=0
M4449 XOR2X1_9/a_18_54# XOR2X1_9/a_13_43# vdd vdd pfet w=40 l=2
+  ad=0.12n pd=86u as=0 ps=0
M4450 XOR2X1_9/a_35_6# shield_coord_y[0] XOR2X1_9/Y Gnd nfet w=20 l=2
+  ad=59.999996p pd=46u as=0 ps=0
M4451 XOR2X1_9/a_18_6# XOR2X1_9/a_13_43# gnd Gnd nfet w=20 l=2
+  ad=0 pd=0 as=0 ps=0
M4452 vdd shield_coord_y[0] XOR2X1_9/a_2_6# vdd pfet w=40 l=2
+  ad=0 pd=0 as=0.2n ps=90u
M4453 vdd player_bullet_coord_y[0] XOR2X1_9/a_35_54# vdd pfet w=40 l=2
+  ad=0 pd=0 as=0.12n ps=86u
M4454 XOR2X1_9/Y shield_coord_y[0] XOR2X1_9/a_18_54# vdd pfet w=40 l=2
+  ad=0.4n pd=100u as=0 ps=0
M4455 XOR2X1_9/a_35_54# XOR2X1_9/a_2_6# XOR2X1_9/Y vdd pfet w=40 l=2
+  ad=0 pd=0 as=0 ps=0
M4456 XOR2X1_9/a_13_43# player_bullet_coord_y[0] vdd vdd pfet w=40 l=2
+  ad=0.2n pd=90u as=0 ps=0
M4457 gnd player_bullet_coord_y[0] XOR2X1_9/a_35_6# Gnd nfet w=20 l=2
+  ad=0 pd=0 as=0 ps=0
M4458 INVX2_105/Y INVX2_105/A gnd Gnd nfet w=20 l=2
+  ad=100p pd=50u as=0 ps=0
M4459 INVX2_105/Y INVX2_105/A vdd vdd pfet w=40 l=2
+  ad=0.2n pd=90u as=0 ps=0
M4460 INVX2_127/Y INVX2_127/A gnd Gnd nfet w=20 l=2
+  ad=100p pd=50u as=0 ps=0
M4461 INVX2_127/Y INVX2_127/A vdd vdd pfet w=40 l=2
+  ad=0.2n pd=90u as=0 ps=0
M4462 INVX2_116/Y INVX2_116/A gnd Gnd nfet w=20 l=2
+  ad=100p pd=50u as=0 ps=0
M4463 INVX2_116/Y INVX2_116/A vdd vdd pfet w=40 l=2
+  ad=0.2n pd=90u as=0 ps=0
M4464 INVX2_138/Y NOR2X1_31/A gnd Gnd nfet w=20 l=2
+  ad=100p pd=50u as=0 ps=0
M4465 INVX2_138/Y NOR2X1_31/A vdd vdd pfet w=40 l=2
+  ad=0.2n pd=90u as=0 ps=0
M4466 NOR2X1_29/B INVX2_149/A gnd Gnd nfet w=20 l=2
+  ad=100p pd=50u as=0 ps=0
M4467 NOR2X1_29/B INVX2_149/A vdd vdd pfet w=40 l=2
+  ad=0.2n pd=90u as=0 ps=0
M4468 gnd player_coord_x[0] OAI21X1_106/a_2_6# Gnd nfet w=20 l=2
+  ad=0 pd=0 as=0.22n ps=0.102m
M4469 vdd INVX2_161/Y OAI21X1_106/Y vdd pfet w=20 l=2
+  ad=0 pd=0 as=0.22n ps=92u
M4470 OAI21X1_106/Y INVX2_161/Y OAI21X1_106/a_2_6# Gnd nfet w=20 l=2
+  ad=100p pd=50u as=0 ps=0
M4471 OAI21X1_106/Y player_coord_x[1] OAI21X1_106/a_9_54# vdd pfet w=40 l=2
+  ad=0 pd=0 as=0.12n ps=86u
M4472 OAI21X1_106/a_9_54# player_coord_x[0] vdd vdd pfet w=40 l=2
+  ad=0 pd=0 as=0 ps=0
M4473 OAI21X1_106/a_2_6# player_coord_x[1] gnd Gnd nfet w=20 l=2
+  ad=0 pd=0 as=0 ps=0
M4474 gnd INVX2_151/A OAI21X1_128/a_2_6# Gnd nfet w=20 l=2
+  ad=0 pd=0 as=0.22n ps=0.102m
M4475 vdd NAND2X1_64/Y AND2X2_25/B vdd pfet w=20 l=2
+  ad=0 pd=0 as=0.22n ps=92u
M4476 AND2X2_25/B NAND2X1_64/Y OAI21X1_128/a_2_6# Gnd nfet w=20 l=2
+  ad=100p pd=50u as=0 ps=0
M4477 AND2X2_25/B NOR2X1_55/A OAI21X1_128/a_9_54# vdd pfet w=40 l=2
+  ad=0 pd=0 as=0.12n ps=86u
M4478 OAI21X1_128/a_9_54# INVX2_151/A vdd vdd pfet w=40 l=2
+  ad=0 pd=0 as=0 ps=0
M4479 OAI21X1_128/a_2_6# NOR2X1_55/A gnd Gnd nfet w=20 l=2
+  ad=0 pd=0 as=0 ps=0
M4480 gnd INVX2_7/Y OAI21X1_117/a_2_6# Gnd nfet w=20 l=2
+  ad=0 pd=0 as=0.22n ps=0.102m
M4481 vdd NAND2X1_60/Y NAND2X1_57/B vdd pfet w=20 l=2
+  ad=0 pd=0 as=0.22n ps=92u
M4482 NAND2X1_57/B NAND2X1_60/Y OAI21X1_117/a_2_6# Gnd nfet w=20 l=2
+  ad=100p pd=50u as=0 ps=0
M4483 NAND2X1_57/B NAND2X1_58/Y OAI21X1_117/a_9_54# vdd pfet w=40 l=2
+  ad=0 pd=0 as=0.12n ps=86u
M4484 OAI21X1_117/a_9_54# INVX2_7/Y vdd vdd pfet w=40 l=2
+  ad=0 pd=0 as=0 ps=0
M4485 OAI21X1_117/a_2_6# NAND2X1_58/Y gnd Gnd nfet w=20 l=2
+  ad=0 pd=0 as=0 ps=0
M4486 gnd invader_2_coord_x[1] OAI21X1_139/a_2_6# Gnd nfet w=20 l=2
+  ad=0 pd=0 as=0.22n ps=0.102m
M4487 vdd OAI21X1_140/Y XNOR2X1_5/B vdd pfet w=20 l=2
+  ad=0 pd=0 as=0.22n ps=92u
M4488 XNOR2X1_5/B OAI21X1_140/Y OAI21X1_139/a_2_6# Gnd nfet w=20 l=2
+  ad=100p pd=50u as=0 ps=0
M4489 XNOR2X1_5/B XOR2X1_13/A OAI21X1_139/a_9_54# vdd pfet w=40 l=2
+  ad=0 pd=0 as=0.12n ps=86u
M4490 OAI21X1_139/a_9_54# invader_2_coord_x[1] vdd vdd pfet w=40 l=2
+  ad=0 pd=0 as=0 ps=0
M4491 OAI21X1_139/a_2_6# XOR2X1_13/A gnd Gnd nfet w=20 l=2
+  ad=0 pd=0 as=0 ps=0
M4492 vdd BUFX2_4/A BUFX2_4/a_2_6# vdd pfet w=20 l=2
+  ad=0 pd=0 as=100p ps=50u
M4493 gnd BUFX2_4/A BUFX2_4/a_2_6# Gnd nfet w=10 l=2
+  ad=0 pd=0 as=50p ps=30u
M4494 BUFX2_4/Y BUFX2_4/a_2_6# vdd vdd pfet w=40 l=2
+  ad=0.2n pd=90u as=0 ps=0
M4495 BUFX2_4/Y BUFX2_4/a_2_6# gnd Gnd nfet w=20 l=2
+  ad=100p pd=50u as=0 ps=0
M4496 INVX2_4/Y invader_bullet_coord_x[2] gnd Gnd nfet w=20 l=2
+  ad=100p pd=50u as=0 ps=0
M4497 INVX2_4/Y invader_bullet_coord_x[2] vdd vdd pfet w=40 l=2
+  ad=0.2n pd=90u as=0 ps=0
M4498 AOI21X1_4/a_2_54# OAI21X1_5/Y vdd vdd pfet w=40 l=2
+  ad=0.44n pd=0.182m as=0 ps=0
M4499 AOI21X1_4/a_12_6# INVX2_51/Y gnd Gnd nfet w=20 l=2
+  ad=59.999996p pd=46u as=0 ps=0
M4500 gnd OAI21X1_3/Y AOI21X1_4/Y Gnd nfet w=10 l=2
+  ad=0 pd=0 as=0.11n ps=52u
M4501 vdd INVX2_51/Y AOI21X1_4/a_2_54# vdd pfet w=40 l=2
+  ad=0 pd=0 as=0 ps=0
M4502 AOI21X1_4/Y OAI21X1_3/Y AOI21X1_4/a_2_54# vdd pfet w=40 l=2
+  ad=0.2n pd=90u as=0 ps=0
M4503 AOI21X1_4/Y OAI21X1_5/Y AOI21X1_4/a_12_6# Gnd nfet w=20 l=2
+  ad=0 pd=0 as=0 ps=0
M4504 NOR2X1_2/Y NOR2X1_2/A gnd Gnd nfet w=10 l=2
+  ad=59.999996p pd=32u as=0 ps=0
M4505 NOR2X1_2/Y INVX2_2/Y NOR2X1_2/a_9_54# vdd pfet w=40 l=2
+  ad=0.2n pd=90u as=0.12n ps=86u
M4506 NOR2X1_2/a_9_54# NOR2X1_2/A vdd vdd pfet w=40 l=2
+  ad=0 pd=0 as=0 ps=0
M4507 gnd INVX2_2/Y NOR2X1_2/Y Gnd nfet w=10 l=2
+  ad=0 pd=0 as=0 ps=0
M4508 AOI21X1_23/a_2_54# INVX2_31/Y vdd vdd pfet w=40 l=2
+  ad=0.44n pd=0.182m as=0 ps=0
M4509 AOI21X1_23/a_12_6# XNOR2X1_1/Y gnd Gnd nfet w=20 l=2
+  ad=59.999996p pd=46u as=0 ps=0
M4510 gnd INVX2_29/Y OAI21X1_61/A Gnd nfet w=10 l=2
+  ad=0 pd=0 as=0.11n ps=52u
M4511 vdd XNOR2X1_1/Y AOI21X1_23/a_2_54# vdd pfet w=40 l=2
+  ad=0 pd=0 as=0 ps=0
M4512 OAI21X1_61/A INVX2_29/Y AOI21X1_23/a_2_54# vdd pfet w=40 l=2
+  ad=0.2n pd=90u as=0 ps=0
M4513 OAI21X1_61/A INVX2_31/Y AOI21X1_23/a_12_6# Gnd nfet w=20 l=2
+  ad=0 pd=0 as=0 ps=0
M4514 AOI21X1_12/a_2_54# OAI21X1_19/Y vdd vdd pfet w=40 l=2
+  ad=0.44n pd=0.182m as=0 ps=0
M4515 AOI21X1_12/a_12_6# INVX2_69/Y gnd Gnd nfet w=20 l=2
+  ad=59.999996p pd=46u as=0 ps=0
M4516 gnd OAI21X1_17/Y AND2X2_15/A Gnd nfet w=10 l=2
+  ad=0 pd=0 as=0.11n ps=52u
M4517 vdd INVX2_69/Y AOI21X1_12/a_2_54# vdd pfet w=40 l=2
+  ad=0 pd=0 as=0 ps=0
M4518 AND2X2_15/A OAI21X1_17/Y AOI21X1_12/a_2_54# vdd pfet w=40 l=2
+  ad=0.2n pd=90u as=0 ps=0
M4519 AND2X2_15/A OAI21X1_19/Y AOI21X1_12/a_12_6# Gnd nfet w=20 l=2
+  ad=0 pd=0 as=0 ps=0
M4520 vdd invader_2_coord_x[3] HAX1_15/a_2_74# vdd pfet w=20 l=2
+  ad=0 pd=0 as=0.2n ps=100u
M4521 HAX1_15/a_41_74# HAX1_15/a_2_74# vdd vdd pfet w=20 l=2
+  ad=0.22n pd=92u as=0 ps=0
M4522 HAX1_15/a_9_6# invader_2_coord_x[3] gnd Gnd nfet w=20 l=2
+  ad=59.999996p pd=46u as=0 ps=0
M4523 HAX1_15/a_41_74# HAX1_15/B HAX1_15/a_38_6# Gnd nfet w=20 l=2
+  ad=0.12n pd=52u as=0.216n ps=0.102m
M4524 vdd invader_2_coord_x[3] HAX1_15/a_49_54# vdd pfet w=40 l=2
+  ad=0 pd=0 as=0.12n ps=86u
M4525 vdd HAX1_15/a_2_74# OR2X1_0/B vdd pfet w=20 l=2
+  ad=0 pd=0 as=100p ps=50u
M4526 HAX1_15/a_38_6# HAX1_15/a_2_74# gnd Gnd nfet w=20 l=2
+  ad=0 pd=0 as=0 ps=0
M4527 INVX2_48/A HAX1_15/a_41_74# vdd vdd pfet w=20 l=2
+  ad=100p pd=50u as=0 ps=0
M4528 HAX1_15/a_38_6# invader_2_coord_x[3] HAX1_15/a_41_74# Gnd nfet w=20 l=2
+  ad=0 pd=0 as=0 ps=0
M4529 INVX2_48/A HAX1_15/a_41_74# gnd Gnd nfet w=10 l=2
+  ad=50p pd=30u as=0 ps=0
M4530 HAX1_15/a_2_74# HAX1_15/B vdd vdd pfet w=20 l=2
+  ad=0 pd=0 as=0 ps=0
M4531 HAX1_15/a_2_74# HAX1_15/B HAX1_15/a_9_6# Gnd nfet w=20 l=2
+  ad=100p pd=50u as=0 ps=0
M4532 HAX1_15/a_49_54# HAX1_15/B HAX1_15/a_41_74# vdd pfet w=40 l=2
+  ad=0 pd=0 as=0 ps=0
M4533 gnd HAX1_15/a_2_74# OR2X1_0/B Gnd nfet w=10 l=2
+  ad=0 pd=0 as=50p ps=30u
M4534 gnd HAX1_13/YS OAI21X1_7/a_2_6# Gnd nfet w=20 l=2
+  ad=0 pd=0 as=0.22n ps=0.102m
M4535 vdd OAI21X1_7/C OAI21X1_7/Y vdd pfet w=20 l=2
+  ad=0 pd=0 as=0.22n ps=92u
M4536 OAI21X1_7/Y OAI21X1_7/C OAI21X1_7/a_2_6# Gnd nfet w=20 l=2
+  ad=100p pd=50u as=0 ps=0
M4537 OAI21X1_7/Y INVX2_15/Y OAI21X1_7/a_9_54# vdd pfet w=40 l=2
+  ad=0 pd=0 as=0.12n ps=86u
M4538 OAI21X1_7/a_9_54# HAX1_13/YS vdd vdd pfet w=40 l=2
+  ad=0 pd=0 as=0 ps=0
M4539 OAI21X1_7/a_2_6# INVX2_15/Y gnd Gnd nfet w=20 l=2
+  ad=0 pd=0 as=0 ps=0
M4540 DFFNEGX1_5/a_76_6# BUFX2_7/Y DFFNEGX1_5/a_66_6# Gnd nfet w=10 l=2
+  ad=29.999998p pd=26u as=80p ps=36u
M4541 gnd BUFX2_7/Y DFFNEGX1_5/a_2_6# Gnd nfet w=20 l=2
+  ad=0 pd=0 as=100p ps=50u
M4542 DFFNEGX1_5/a_66_6# DFFNEGX1_5/a_2_6# DFFNEGX1_5/a_61_6# Gnd nfet w=10 l=2
+  ad=0 pd=0 as=29.999998p ps=26u
M4543 invader_bullet_coord_x[3] DFFNEGX1_5/a_66_6# gnd Gnd nfet w=20 l=2
+  ad=100p pd=50u as=0 ps=0
M4544 DFFNEGX1_5/a_23_6# BUFX2_7/Y DFFNEGX1_5/a_17_6# Gnd nfet w=10 l=2
+  ad=59.999996p pd=32u as=40p ps=28u
M4545 DFFNEGX1_5/a_23_6# DFFNEGX1_5/a_2_6# DFFNEGX1_5/a_17_74# vdd pfet w=20 l=2
+  ad=0.12n pd=52u as=80p ps=48u
M4546 gnd DFFNEGX1_5/a_34_4# DFFNEGX1_5/a_31_6# Gnd nfet w=10 l=2
+  ad=0 pd=0 as=29.999998p ps=26u
M4547 vdd DFFNEGX1_5/a_34_4# DFFNEGX1_5/a_31_74# vdd pfet w=20 l=2
+  ad=0 pd=0 as=80p ps=48u
M4548 DFFNEGX1_5/a_61_74# DFFNEGX1_5/a_34_4# vdd vdd pfet w=20 l=2
+  ad=59.999996p pd=46u as=0 ps=0
M4549 DFFNEGX1_5/a_34_4# DFFNEGX1_5/a_23_6# vdd vdd pfet w=20 l=2
+  ad=100p pd=50u as=0 ps=0
M4550 DFFNEGX1_5/a_34_4# DFFNEGX1_5/a_23_6# gnd Gnd nfet w=10 l=2
+  ad=50p pd=30u as=0 ps=0
M4551 vdd invader_bullet_coord_x[3] DFFNEGX1_5/a_76_84# vdd pfet w=10 l=2
+  ad=0 pd=0 as=29.999998p ps=26u
M4552 gnd invader_bullet_coord_x[3] DFFNEGX1_5/a_76_6# Gnd nfet w=10 l=2
+  ad=0 pd=0 as=0 ps=0
M4553 DFFNEGX1_5/a_61_6# DFFNEGX1_5/a_34_4# gnd Gnd nfet w=10 l=2
+  ad=0 pd=0 as=0 ps=0
M4554 DFFNEGX1_5/a_76_84# DFFNEGX1_5/a_2_6# DFFNEGX1_5/a_66_6# vdd pfet w=10 l=2
+  ad=0 pd=0 as=0.15n ps=56u
M4555 invader_bullet_coord_x[3] DFFNEGX1_5/a_66_6# vdd vdd pfet w=40 l=2
+  ad=0.2n pd=90u as=0 ps=0
M4556 vdd BUFX2_7/Y DFFNEGX1_5/a_2_6# vdd pfet w=40 l=2
+  ad=0 pd=0 as=0.2n ps=90u
M4557 DFFNEGX1_5/a_31_6# DFFNEGX1_5/a_2_6# DFFNEGX1_5/a_23_6# Gnd nfet w=10 l=2
+  ad=0 pd=0 as=0 ps=0
M4558 DFFNEGX1_5/a_66_6# BUFX2_7/Y DFFNEGX1_5/a_61_74# vdd pfet w=20 l=2
+  ad=0 pd=0 as=0 ps=0
M4559 DFFNEGX1_5/a_17_74# OAI21X1_42/Y vdd vdd pfet w=20 l=2
+  ad=0 pd=0 as=0 ps=0
M4560 DFFNEGX1_5/a_31_74# BUFX2_7/Y DFFNEGX1_5/a_23_6# vdd pfet w=20 l=2
+  ad=0 pd=0 as=0 ps=0
M4561 DFFNEGX1_5/a_17_6# OAI21X1_42/Y gnd Gnd nfet w=10 l=2
+  ad=0 pd=0 as=0 ps=0
M4562 NOR2X1_59/A INVX2_128/A gnd Gnd nfet w=20 l=2
+  ad=100p pd=50u as=0 ps=0
M4563 NOR2X1_59/A INVX2_128/A vdd vdd pfet w=40 l=2
+  ad=0.2n pd=90u as=0 ps=0
M4564 INVX2_117/Y INVX2_117/A gnd Gnd nfet w=20 l=2
+  ad=100p pd=50u as=0 ps=0
M4565 INVX2_117/Y INVX2_117/A vdd vdd pfet w=40 l=2
+  ad=0.2n pd=90u as=0 ps=0
M4566 INVX2_106/Y INVX2_106/A gnd Gnd nfet w=20 l=2
+  ad=100p pd=50u as=0 ps=0
M4567 INVX2_106/Y INVX2_106/A vdd vdd pfet w=40 l=2
+  ad=0.2n pd=90u as=0 ps=0
M4568 NAND2X1_3/A INVX2_139/A gnd Gnd nfet w=20 l=2
+  ad=100p pd=50u as=0 ps=0
M4569 NAND2X1_3/A INVX2_139/A vdd vdd pfet w=40 l=2
+  ad=0.2n pd=90u as=0 ps=0
M4570 gnd INVX2_124/A OAI21X1_129/a_2_6# Gnd nfet w=20 l=2
+  ad=0 pd=0 as=0.22n ps=0.102m
M4571 vdd OAI21X1_130/Y NAND2X1_64/B vdd pfet w=20 l=2
+  ad=0 pd=0 as=0.22n ps=92u
M4572 NAND2X1_64/B OAI21X1_130/Y OAI21X1_129/a_2_6# Gnd nfet w=20 l=2
+  ad=100p pd=50u as=0 ps=0
M4573 NAND2X1_64/B INVX2_150/Y OAI21X1_129/a_9_54# vdd pfet w=40 l=2
+  ad=0 pd=0 as=0.12n ps=86u
M4574 OAI21X1_129/a_9_54# INVX2_124/A vdd vdd pfet w=40 l=2
+  ad=0 pd=0 as=0 ps=0
M4575 OAI21X1_129/a_2_6# INVX2_150/Y gnd Gnd nfet w=20 l=2
+  ad=0 pd=0 as=0 ps=0
M4576 gnd INVX2_164/Y OAI21X1_107/a_2_6# Gnd nfet w=20 l=2
+  ad=0 pd=0 as=0.22n ps=0.102m
M4577 vdd AND2X2_19/Y OR2X1_14/B vdd pfet w=20 l=2
+  ad=0 pd=0 as=0.22n ps=92u
M4578 OR2X1_14/B AND2X2_19/Y OAI21X1_107/a_2_6# Gnd nfet w=20 l=2
+  ad=100p pd=50u as=0 ps=0
M4579 OR2X1_14/B OR2X1_17/A OAI21X1_107/a_9_54# vdd pfet w=40 l=2
+  ad=0 pd=0 as=0.12n ps=86u
M4580 OAI21X1_107/a_9_54# INVX2_164/Y vdd vdd pfet w=40 l=2
+  ad=0 pd=0 as=0 ps=0
M4581 OAI21X1_107/a_2_6# OR2X1_17/A gnd Gnd nfet w=20 l=2
+  ad=0 pd=0 as=0 ps=0
M4582 gnd player_coord_x[3] OAI21X1_118/a_2_6# Gnd nfet w=20 l=2
+  ad=0 pd=0 as=0.22n ps=0.102m
M4583 vdd OAI21X1_119/Y AOI22X1_45/B vdd pfet w=20 l=2
+  ad=0 pd=0 as=0.22n ps=92u
M4584 AOI22X1_45/B OAI21X1_119/Y OAI21X1_118/a_2_6# Gnd nfet w=20 l=2
+  ad=100p pd=50u as=0 ps=0
M4585 AOI22X1_45/B INVX2_6/Y OAI21X1_118/a_9_54# vdd pfet w=40 l=2
+  ad=0 pd=0 as=0.12n ps=86u
M4586 OAI21X1_118/a_9_54# player_coord_x[3] vdd vdd pfet w=40 l=2
+  ad=0 pd=0 as=0 ps=0
M4587 OAI21X1_118/a_2_6# INVX2_6/Y gnd Gnd nfet w=20 l=2
+  ad=0 pd=0 as=0 ps=0
M4588 vdd BUFX2_7/A BUFX2_5/a_2_6# vdd pfet w=20 l=2
+  ad=0 pd=0 as=100p ps=50u
M4589 gnd BUFX2_7/A BUFX2_5/a_2_6# Gnd nfet w=10 l=2
+  ad=0 pd=0 as=50p ps=30u
M4590 BUFX2_5/Y BUFX2_5/a_2_6# vdd vdd pfet w=40 l=2
+  ad=0.2n pd=90u as=0 ps=0
M4591 BUFX2_5/Y BUFX2_5/a_2_6# gnd Gnd nfet w=20 l=2
+  ad=100p pd=50u as=0 ps=0
M4592 NAND2X1_0/Y NAND2X1_0/A vdd vdd pfet w=20 l=2
+  ad=0.12n pd=52u as=0 ps=0
M4593 NAND2X1_0/a_9_6# NAND2X1_0/A gnd Gnd nfet w=20 l=2
+  ad=59.999996p pd=46u as=0 ps=0
M4594 vdd NAND2X1_0/B NAND2X1_0/Y vdd pfet w=20 l=2
+  ad=0 pd=0 as=0 ps=0
M4595 NAND2X1_0/Y NAND2X1_0/B NAND2X1_0/a_9_6# Gnd nfet w=20 l=2
+  ad=100p pd=50u as=0 ps=0
M4596 INVX2_5/Y INVX2_5/A gnd Gnd nfet w=20 l=2
+  ad=100p pd=50u as=0 ps=0
M4597 INVX2_5/Y INVX2_5/A vdd vdd pfet w=40 l=2
+  ad=0.2n pd=90u as=0 ps=0
M4598 AOI21X1_5/a_2_54# INVX2_22/Y vdd vdd pfet w=40 l=2
+  ad=0.44n pd=0.182m as=0 ps=0
M4599 AOI21X1_5/a_12_6# INVX2_34/A gnd Gnd nfet w=20 l=2
+  ad=59.999996p pd=46u as=0 ps=0
M4600 gnd AOI22X1_3/Y AOI22X1_2/A Gnd nfet w=10 l=2
+  ad=0 pd=0 as=0.11n ps=52u
M4601 vdd INVX2_34/A AOI21X1_5/a_2_54# vdd pfet w=40 l=2
+  ad=0 pd=0 as=0 ps=0
M4602 AOI22X1_2/A AOI22X1_3/Y AOI21X1_5/a_2_54# vdd pfet w=40 l=2
+  ad=0.2n pd=90u as=0 ps=0
M4603 AOI22X1_2/A INVX2_22/Y AOI21X1_5/a_12_6# Gnd nfet w=20 l=2
+  ad=0 pd=0 as=0 ps=0
M4604 NOR2X1_3/Y NOR2X1_3/A gnd Gnd nfet w=10 l=2
+  ad=59.999996p pd=32u as=0 ps=0
M4605 NOR2X1_3/Y OR2X1_15/A NOR2X1_3/a_9_54# vdd pfet w=40 l=2
+  ad=0.2n pd=90u as=0.12n ps=86u
M4606 NOR2X1_3/a_9_54# NOR2X1_3/A vdd vdd pfet w=40 l=2
+  ad=0 pd=0 as=0 ps=0
M4607 gnd OR2X1_15/A NOR2X1_3/Y Gnd nfet w=10 l=2
+  ad=0 pd=0 as=0 ps=0
M4608 AOI21X1_13/a_2_54# INVX2_22/Y vdd vdd pfet w=40 l=2
+  ad=0.44n pd=0.182m as=0 ps=0
M4609 AOI21X1_13/a_12_6# HAX1_8/YS gnd Gnd nfet w=20 l=2
+  ad=59.999996p pd=46u as=0 ps=0
M4610 gnd AOI22X1_7/Y AOI22X1_6/A Gnd nfet w=10 l=2
+  ad=0 pd=0 as=0.11n ps=52u
M4611 vdd HAX1_8/YS AOI21X1_13/a_2_54# vdd pfet w=40 l=2
+  ad=0 pd=0 as=0 ps=0
M4612 AOI22X1_6/A AOI22X1_7/Y AOI21X1_13/a_2_54# vdd pfet w=40 l=2
+  ad=0.2n pd=90u as=0 ps=0
M4613 AOI22X1_6/A INVX2_22/Y AOI21X1_13/a_12_6# Gnd nfet w=20 l=2
+  ad=0 pd=0 as=0 ps=0
M4614 AOI21X1_24/a_2_54# INVX2_71/Y vdd vdd pfet w=40 l=2
+  ad=0.44n pd=0.182m as=0 ps=0
M4615 AOI21X1_24/a_12_6# XNOR2X1_2/Y gnd Gnd nfet w=20 l=2
+  ad=59.999996p pd=46u as=0 ps=0
M4616 gnd INVX2_59/Y OAI21X1_81/A Gnd nfet w=10 l=2
+  ad=0 pd=0 as=0.11n ps=52u
M4617 vdd XNOR2X1_2/Y AOI21X1_24/a_2_54# vdd pfet w=40 l=2
+  ad=0 pd=0 as=0 ps=0
M4618 OAI21X1_81/A INVX2_59/Y AOI21X1_24/a_2_54# vdd pfet w=40 l=2
+  ad=0.2n pd=90u as=0 ps=0
M4619 OAI21X1_81/A INVX2_71/Y AOI21X1_24/a_12_6# Gnd nfet w=20 l=2
+  ad=0 pd=0 as=0 ps=0
M4620 vdd invader_2_coord_x[2] HAX1_16/a_2_74# vdd pfet w=20 l=2
+  ad=0 pd=0 as=0.2n ps=100u
M4621 HAX1_16/a_41_74# HAX1_16/a_2_74# vdd vdd pfet w=20 l=2
+  ad=0.22n pd=92u as=0 ps=0
M4622 HAX1_16/a_9_6# invader_2_coord_x[2] gnd Gnd nfet w=20 l=2
+  ad=59.999996p pd=46u as=0 ps=0
M4623 HAX1_16/a_41_74# HAX1_16/B HAX1_16/a_38_6# Gnd nfet w=20 l=2
+  ad=0.12n pd=52u as=0.216n ps=0.102m
M4624 vdd invader_2_coord_x[2] HAX1_16/a_49_54# vdd pfet w=40 l=2
+  ad=0 pd=0 as=0.12n ps=86u
M4625 vdd HAX1_16/a_2_74# HAX1_15/B vdd pfet w=20 l=2
+  ad=0 pd=0 as=100p ps=50u
M4626 HAX1_16/a_38_6# HAX1_16/a_2_74# gnd Gnd nfet w=20 l=2
+  ad=0 pd=0 as=0 ps=0
M4627 HAX1_16/YS HAX1_16/a_41_74# vdd vdd pfet w=20 l=2
+  ad=100p pd=50u as=0 ps=0
M4628 HAX1_16/a_38_6# invader_2_coord_x[2] HAX1_16/a_41_74# Gnd nfet w=20 l=2
+  ad=0 pd=0 as=0 ps=0
M4629 HAX1_16/YS HAX1_16/a_41_74# gnd Gnd nfet w=10 l=2
+  ad=50p pd=30u as=0 ps=0
M4630 HAX1_16/a_2_74# HAX1_16/B vdd vdd pfet w=20 l=2
+  ad=0 pd=0 as=0 ps=0
M4631 HAX1_16/a_2_74# HAX1_16/B HAX1_16/a_9_6# Gnd nfet w=20 l=2
+  ad=100p pd=50u as=0 ps=0
M4632 HAX1_16/a_49_54# HAX1_16/B HAX1_16/a_41_74# vdd pfet w=40 l=2
+  ad=0 pd=0 as=0 ps=0
M4633 gnd HAX1_16/a_2_74# HAX1_15/B Gnd nfet w=10 l=2
+  ad=0 pd=0 as=50p ps=30u
M4634 gnd player_bullet_coord_y[3] OAI21X1_8/a_2_6# Gnd nfet w=20 l=2
+  ad=0 pd=0 as=0.22n ps=0.102m
M4635 vdd OAI21X1_8/C INVX2_40/A vdd pfet w=20 l=2
+  ad=0 pd=0 as=0.22n ps=92u
M4636 INVX2_40/A OAI21X1_8/C OAI21X1_8/a_2_6# Gnd nfet w=20 l=2
+  ad=100p pd=50u as=0 ps=0
M4637 INVX2_40/A INVX2_39/Y OAI21X1_8/a_9_54# vdd pfet w=40 l=2
+  ad=0 pd=0 as=0.12n ps=86u
M4638 OAI21X1_8/a_9_54# player_bullet_coord_y[3] vdd vdd pfet w=40 l=2
+  ad=0 pd=0 as=0 ps=0
M4639 OAI21X1_8/a_2_6# INVX2_39/Y gnd Gnd nfet w=20 l=2
+  ad=0 pd=0 as=0 ps=0
M4640 OR2X1_0/a_2_54# OR2X1_0/A gnd Gnd nfet w=10 l=2
+  ad=29.999998p pd=16u as=50p ps=30u
M4641 OR2X1_0/Y OR2X1_0/a_2_54# vdd vdd pfet w=20 l=2
+  ad=100p pd=50u as=0.11n ps=46u
M4642 OR2X1_0/Y OR2X1_0/a_2_54# gnd Gnd nfet w=10 l=2
+  ad=50p pd=30u as=29.999998p ps=16u
M4643 vdd OR2X1_0/B OR2X1_0/a_9_54# vdd pfet w=40 l=2
+  ad=0.11n pd=46u as=59.999996p ps=43u
M4644 OR2X1_0/a_9_54# OR2X1_0/A OR2X1_0/a_2_54# vdd pfet w=40 l=2
+  ad=59.999996p pd=43u as=0.2n ps=90u
M4645 gnd OR2X1_0/B OR2X1_0/a_2_54# Gnd nfet w=10 l=2
+  ad=29.999998p pd=16u as=29.999998p ps=16u
M4646 DFFNEGX1_6/a_76_6# BUFX2_7/Y DFFNEGX1_6/a_66_6# Gnd nfet w=10 l=2
+  ad=29.999998p pd=26u as=80p ps=36u
M4647 gnd BUFX2_7/Y DFFNEGX1_6/a_2_6# Gnd nfet w=20 l=2
+  ad=0 pd=0 as=100p ps=50u
M4648 DFFNEGX1_6/a_66_6# DFFNEGX1_6/a_2_6# DFFNEGX1_6/a_61_6# Gnd nfet w=10 l=2
+  ad=0 pd=0 as=29.999998p ps=26u
M4649 invader_bullet_coord_x[0] DFFNEGX1_6/a_66_6# gnd Gnd nfet w=20 l=2
+  ad=100p pd=50u as=0 ps=0
M4650 DFFNEGX1_6/a_23_6# BUFX2_7/Y DFFNEGX1_6/a_17_6# Gnd nfet w=10 l=2
+  ad=59.999996p pd=32u as=40p ps=28u
M4651 DFFNEGX1_6/a_23_6# DFFNEGX1_6/a_2_6# DFFNEGX1_6/a_17_74# vdd pfet w=20 l=2
+  ad=0.12n pd=52u as=80p ps=48u
M4652 gnd DFFNEGX1_6/a_34_4# DFFNEGX1_6/a_31_6# Gnd nfet w=10 l=2
+  ad=0 pd=0 as=29.999998p ps=26u
M4653 vdd DFFNEGX1_6/a_34_4# DFFNEGX1_6/a_31_74# vdd pfet w=20 l=2
+  ad=0 pd=0 as=80p ps=48u
M4654 DFFNEGX1_6/a_61_74# DFFNEGX1_6/a_34_4# vdd vdd pfet w=20 l=2
+  ad=59.999996p pd=46u as=0 ps=0
M4655 DFFNEGX1_6/a_34_4# DFFNEGX1_6/a_23_6# vdd vdd pfet w=20 l=2
+  ad=100p pd=50u as=0 ps=0
M4656 DFFNEGX1_6/a_34_4# DFFNEGX1_6/a_23_6# gnd Gnd nfet w=10 l=2
+  ad=50p pd=30u as=0 ps=0
M4657 vdd invader_bullet_coord_x[0] DFFNEGX1_6/a_76_84# vdd pfet w=10 l=2
+  ad=0 pd=0 as=29.999998p ps=26u
M4658 gnd invader_bullet_coord_x[0] DFFNEGX1_6/a_76_6# Gnd nfet w=10 l=2
+  ad=0 pd=0 as=0 ps=0
M4659 DFFNEGX1_6/a_61_6# DFFNEGX1_6/a_34_4# gnd Gnd nfet w=10 l=2
+  ad=0 pd=0 as=0 ps=0
M4660 DFFNEGX1_6/a_76_84# DFFNEGX1_6/a_2_6# DFFNEGX1_6/a_66_6# vdd pfet w=10 l=2
+  ad=0 pd=0 as=0.15n ps=56u
M4661 invader_bullet_coord_x[0] DFFNEGX1_6/a_66_6# vdd vdd pfet w=40 l=2
+  ad=0.2n pd=90u as=0 ps=0
M4662 vdd BUFX2_7/Y DFFNEGX1_6/a_2_6# vdd pfet w=40 l=2
+  ad=0 pd=0 as=0.2n ps=90u
M4663 DFFNEGX1_6/a_31_6# DFFNEGX1_6/a_2_6# DFFNEGX1_6/a_23_6# Gnd nfet w=10 l=2
+  ad=0 pd=0 as=0 ps=0
M4664 DFFNEGX1_6/a_66_6# BUFX2_7/Y DFFNEGX1_6/a_61_74# vdd pfet w=20 l=2
+  ad=0 pd=0 as=0 ps=0
M4665 DFFNEGX1_6/a_17_74# OAI21X1_44/Y vdd vdd pfet w=20 l=2
+  ad=0 pd=0 as=0 ps=0
M4666 DFFNEGX1_6/a_31_74# BUFX2_7/Y DFFNEGX1_6/a_23_6# vdd pfet w=20 l=2
+  ad=0 pd=0 as=0 ps=0
M4667 DFFNEGX1_6/a_17_6# OAI21X1_44/Y gnd Gnd nfet w=10 l=2
+  ad=0 pd=0 as=0 ps=0
M4668 INVX2_118/Y INVX2_118/A gnd Gnd nfet w=20 l=2
+  ad=100p pd=50u as=0 ps=0
M4669 INVX2_118/Y INVX2_118/A vdd vdd pfet w=40 l=2
+  ad=0.2n pd=90u as=0 ps=0
M4670 OAI22X1_9/A INVX2_107/A gnd Gnd nfet w=20 l=2
+  ad=100p pd=50u as=0 ps=0
M4671 OAI22X1_9/A INVX2_107/A vdd vdd pfet w=40 l=2
+  ad=0.2n pd=90u as=0 ps=0
M4672 OAI22X1_5/D NOR2X1_34/Y gnd Gnd nfet w=20 l=2
+  ad=100p pd=50u as=0 ps=0
M4673 OAI22X1_5/D NOR2X1_34/Y vdd vdd pfet w=40 l=2
+  ad=0.2n pd=90u as=0 ps=0
M4674 gnd INVX2_131/Y OAI21X1_108/a_2_6# Gnd nfet w=20 l=2
+  ad=0 pd=0 as=0.22n ps=0.102m
M4675 vdd NAND3X1_42/Y OR2X1_14/A vdd pfet w=20 l=2
+  ad=0 pd=0 as=0.22n ps=92u
M4676 OR2X1_14/A NAND3X1_42/Y OAI21X1_108/a_2_6# Gnd nfet w=20 l=2
+  ad=100p pd=50u as=0 ps=0
M4677 OR2X1_14/A AOI21X1_26/Y OAI21X1_108/a_9_54# vdd pfet w=40 l=2
+  ad=0 pd=0 as=0.12n ps=86u
M4678 OAI21X1_108/a_9_54# INVX2_131/Y vdd vdd pfet w=40 l=2
+  ad=0 pd=0 as=0 ps=0
M4679 OAI21X1_108/a_2_6# AOI21X1_26/Y gnd Gnd nfet w=20 l=2
+  ad=0 pd=0 as=0 ps=0
M4680 gnd invader_bullet_coord_x[3] OAI21X1_119/a_2_6# Gnd nfet w=20 l=2
+  ad=0 pd=0 as=0.22n ps=0.102m
M4681 vdd AOI22X1_46/Y OAI21X1_119/Y vdd pfet w=20 l=2
+  ad=0 pd=0 as=0.22n ps=92u
M4682 OAI21X1_119/Y AOI22X1_46/Y OAI21X1_119/a_2_6# Gnd nfet w=20 l=2
+  ad=100p pd=50u as=0 ps=0
M4683 OAI21X1_119/Y INVX2_182/Y OAI21X1_119/a_9_54# vdd pfet w=40 l=2
+  ad=0 pd=0 as=0.12n ps=86u
M4684 OAI21X1_119/a_9_54# invader_bullet_coord_x[3] vdd vdd pfet w=40 l=2
+  ad=0 pd=0 as=0 ps=0
M4685 OAI21X1_119/a_2_6# INVX2_182/Y gnd Gnd nfet w=20 l=2
+  ad=0 pd=0 as=0 ps=0
M4686 vdd BUFX2_7/A BUFX2_6/a_2_6# vdd pfet w=20 l=2
+  ad=0 pd=0 as=100p ps=50u
M4687 gnd BUFX2_7/A BUFX2_6/a_2_6# Gnd nfet w=10 l=2
+  ad=0 pd=0 as=50p ps=30u
M4688 BUFX2_6/Y BUFX2_6/a_2_6# vdd vdd pfet w=40 l=2
+  ad=0.2n pd=90u as=0 ps=0
M4689 BUFX2_6/Y BUFX2_6/a_2_6# gnd Gnd nfet w=20 l=2
+  ad=100p pd=50u as=0 ps=0
M4690 NAND2X1_1/Y INVX2_2/A vdd vdd pfet w=20 l=2
+  ad=0.12n pd=52u as=0 ps=0
M4691 NAND2X1_1/a_9_6# INVX2_2/A gnd Gnd nfet w=20 l=2
+  ad=59.999996p pd=46u as=0 ps=0
M4692 vdd NAND2X1_1/B NAND2X1_1/Y vdd pfet w=20 l=2
+  ad=0 pd=0 as=0 ps=0
M4693 NAND2X1_1/Y NAND2X1_1/B NAND2X1_1/a_9_6# Gnd nfet w=20 l=2
+  ad=100p pd=50u as=0 ps=0
M4694 INVX2_6/Y invader_bullet_coord_x[3] gnd Gnd nfet w=20 l=2
+  ad=100p pd=50u as=0 ps=0
M4695 INVX2_6/Y invader_bullet_coord_x[3] vdd vdd pfet w=40 l=2
+  ad=0.2n pd=90u as=0 ps=0
M4696 AOI21X1_6/a_2_54# invader_2_coord_y[3] vdd vdd pfet w=40 l=2
+  ad=0.44n pd=0.182m as=0 ps=0
M4697 AOI21X1_6/a_12_6# NOR2X1_7/A gnd Gnd nfet w=20 l=2
+  ad=59.999996p pd=46u as=0 ps=0
M4698 gnd NOR2X1_7/Y INVX2_41/A Gnd nfet w=10 l=2
+  ad=0 pd=0 as=0.11n ps=52u
M4699 vdd NOR2X1_7/A AOI21X1_6/a_2_54# vdd pfet w=40 l=2
+  ad=0 pd=0 as=0 ps=0
M4700 INVX2_41/A NOR2X1_7/Y AOI21X1_6/a_2_54# vdd pfet w=40 l=2
+  ad=0.2n pd=90u as=0 ps=0
M4701 INVX2_41/A invader_2_coord_y[3] AOI21X1_6/a_12_6# Gnd nfet w=20 l=2
+  ad=0 pd=0 as=0 ps=0
M4702 NOR2X1_4/Y invader_bullet_coord_y[3] gnd Gnd nfet w=10 l=2
+  ad=59.999996p pd=32u as=0 ps=0
M4703 NOR2X1_4/Y NOR2X1_4/B NOR2X1_4/a_9_54# vdd pfet w=40 l=2
+  ad=0.2n pd=90u as=0.12n ps=86u
M4704 NOR2X1_4/a_9_54# invader_bullet_coord_y[3] vdd vdd pfet w=40 l=2
+  ad=0 pd=0 as=0 ps=0
M4705 gnd NOR2X1_4/B NOR2X1_4/Y Gnd nfet w=10 l=2
+  ad=0 pd=0 as=0 ps=0
M4706 AOI21X1_25/a_2_54# INVX2_89/Y vdd vdd pfet w=40 l=2
+  ad=0.44n pd=0.182m as=0 ps=0
M4707 AOI21X1_25/a_12_6# NAND2X1_1/B gnd Gnd nfet w=20 l=2
+  ad=59.999996p pd=46u as=0 ps=0
M4708 gnd AND2X2_17/Y OAI21X1_97/A Gnd nfet w=10 l=2
+  ad=0 pd=0 as=0.11n ps=52u
M4709 vdd NAND2X1_1/B AOI21X1_25/a_2_54# vdd pfet w=40 l=2
+  ad=0 pd=0 as=0 ps=0
M4710 OAI21X1_97/A AND2X2_17/Y AOI21X1_25/a_2_54# vdd pfet w=40 l=2
+  ad=0.2n pd=90u as=0 ps=0
M4711 OAI21X1_97/A INVX2_89/Y AOI21X1_25/a_12_6# Gnd nfet w=20 l=2
+  ad=0 pd=0 as=0 ps=0
M4712 AOI21X1_14/a_2_54# invader_1_coord_y[3] vdd vdd pfet w=40 l=2
+  ad=0.44n pd=0.182m as=0 ps=0
M4713 AOI21X1_14/a_12_6# NOR2X1_11/A gnd Gnd nfet w=20 l=2
+  ad=59.999996p pd=46u as=0 ps=0
M4714 gnd INVX2_81/A INVX2_79/A Gnd nfet w=10 l=2
+  ad=0 pd=0 as=0.11n ps=52u
M4715 vdd NOR2X1_11/A AOI21X1_14/a_2_54# vdd pfet w=40 l=2
+  ad=0 pd=0 as=0 ps=0
M4716 INVX2_79/A INVX2_81/A AOI21X1_14/a_2_54# vdd pfet w=40 l=2
+  ad=0.2n pd=90u as=0 ps=0
M4717 INVX2_79/A invader_1_coord_y[3] AOI21X1_14/a_12_6# Gnd nfet w=20 l=2
+  ad=0 pd=0 as=0 ps=0
M4718 vdd invader_2_coord_x[1] HAX1_17/a_2_74# vdd pfet w=20 l=2
+  ad=0 pd=0 as=0.2n ps=100u
M4719 HAX1_17/a_41_74# HAX1_17/a_2_74# vdd vdd pfet w=20 l=2
+  ad=0.22n pd=92u as=0 ps=0
M4720 HAX1_17/a_9_6# invader_2_coord_x[1] gnd Gnd nfet w=20 l=2
+  ad=59.999996p pd=46u as=0 ps=0
M4721 HAX1_17/a_41_74# invader_2_coord_x[0] HAX1_17/a_38_6# Gnd nfet w=20 l=2
+  ad=0.12n pd=52u as=0.216n ps=0.102m
M4722 vdd invader_2_coord_x[1] HAX1_17/a_49_54# vdd pfet w=40 l=2
+  ad=0 pd=0 as=0.12n ps=86u
M4723 vdd HAX1_17/a_2_74# HAX1_16/B vdd pfet w=20 l=2
+  ad=0 pd=0 as=100p ps=50u
M4724 HAX1_17/a_38_6# HAX1_17/a_2_74# gnd Gnd nfet w=20 l=2
+  ad=0 pd=0 as=0 ps=0
M4725 INVX2_45/A HAX1_17/a_41_74# vdd vdd pfet w=20 l=2
+  ad=100p pd=50u as=0 ps=0
M4726 HAX1_17/a_38_6# invader_2_coord_x[1] HAX1_17/a_41_74# Gnd nfet w=20 l=2
+  ad=0 pd=0 as=0 ps=0
M4727 INVX2_45/A HAX1_17/a_41_74# gnd Gnd nfet w=10 l=2
+  ad=50p pd=30u as=0 ps=0
M4728 HAX1_17/a_2_74# invader_2_coord_x[0] vdd vdd pfet w=20 l=2
+  ad=0 pd=0 as=0 ps=0
M4729 HAX1_17/a_2_74# invader_2_coord_x[0] HAX1_17/a_9_6# Gnd nfet w=20 l=2
+  ad=100p pd=50u as=0 ps=0
M4730 HAX1_17/a_49_54# invader_2_coord_x[0] HAX1_17/a_41_74# vdd pfet w=40 l=2
+  ad=0 pd=0 as=0 ps=0
M4731 gnd HAX1_17/a_2_74# HAX1_16/B Gnd nfet w=10 l=2
+  ad=0 pd=0 as=50p ps=30u
M4732 OR2X1_1/a_2_54# OR2X1_1/A gnd Gnd nfet w=10 l=2
+  ad=59.999996p pd=32u as=0 ps=0
M4733 OR2X1_1/Y OR2X1_1/a_2_54# vdd vdd pfet w=20 l=2
+  ad=100p pd=50u as=0 ps=0
M4734 OR2X1_1/Y OR2X1_1/a_2_54# gnd Gnd nfet w=10 l=2
+  ad=50p pd=30u as=0 ps=0
M4735 vdd OR2X1_1/B OR2X1_1/a_9_54# vdd pfet w=40 l=2
+  ad=0 pd=0 as=0.12n ps=86u
M4736 OR2X1_1/a_9_54# OR2X1_1/A OR2X1_1/a_2_54# vdd pfet w=40 l=2
+  ad=0 pd=0 as=0.2n ps=90u
M4737 gnd OR2X1_1/B OR2X1_1/a_2_54# Gnd nfet w=10 l=2
+  ad=0 pd=0 as=0 ps=0
M4738 gnd NOR2X1_8/Y OAI21X1_9/a_2_6# Gnd nfet w=20 l=2
+  ad=0 pd=0 as=0.22n ps=0.102m
M4739 vdd NOR2X1_7/A INVX2_37/A vdd pfet w=20 l=2
+  ad=0 pd=0 as=0.22n ps=92u
M4740 INVX2_37/A NOR2X1_7/A OAI21X1_9/a_2_6# Gnd nfet w=20 l=2
+  ad=100p pd=50u as=0 ps=0
M4741 INVX2_37/A INVX2_36/Y OAI21X1_9/a_9_54# vdd pfet w=40 l=2
+  ad=0 pd=0 as=0.12n ps=86u
M4742 OAI21X1_9/a_9_54# NOR2X1_8/Y vdd vdd pfet w=40 l=2
+  ad=0 pd=0 as=0 ps=0
M4743 OAI21X1_9/a_2_6# INVX2_36/Y gnd Gnd nfet w=20 l=2
+  ad=0 pd=0 as=0 ps=0
M4744 DFFNEGX1_7/a_76_6# BUFX2_7/Y DFFNEGX1_7/a_66_6# Gnd nfet w=10 l=2
+  ad=29.999998p pd=26u as=80p ps=36u
M4745 gnd BUFX2_7/Y DFFNEGX1_7/a_2_6# Gnd nfet w=20 l=2
+  ad=0 pd=0 as=100p ps=50u
M4746 DFFNEGX1_7/a_66_6# DFFNEGX1_7/a_2_6# DFFNEGX1_7/a_61_6# Gnd nfet w=10 l=2
+  ad=0 pd=0 as=29.999998p ps=26u
M4747 INVX2_10/A DFFNEGX1_7/a_66_6# gnd Gnd nfet w=20 l=2
+  ad=100p pd=50u as=0 ps=0
M4748 DFFNEGX1_7/a_23_6# BUFX2_7/Y DFFNEGX1_7/a_17_6# Gnd nfet w=10 l=2
+  ad=59.999996p pd=32u as=40p ps=28u
M4749 DFFNEGX1_7/a_23_6# DFFNEGX1_7/a_2_6# DFFNEGX1_7/a_17_74# vdd pfet w=20 l=2
+  ad=0.12n pd=52u as=80p ps=48u
M4750 gnd DFFNEGX1_7/a_34_4# DFFNEGX1_7/a_31_6# Gnd nfet w=10 l=2
+  ad=0 pd=0 as=29.999998p ps=26u
M4751 vdd DFFNEGX1_7/a_34_4# DFFNEGX1_7/a_31_74# vdd pfet w=20 l=2
+  ad=0 pd=0 as=80p ps=48u
M4752 DFFNEGX1_7/a_61_74# DFFNEGX1_7/a_34_4# vdd vdd pfet w=20 l=2
+  ad=59.999996p pd=46u as=0 ps=0
M4753 DFFNEGX1_7/a_34_4# DFFNEGX1_7/a_23_6# vdd vdd pfet w=20 l=2
+  ad=100p pd=50u as=0 ps=0
M4754 DFFNEGX1_7/a_34_4# DFFNEGX1_7/a_23_6# gnd Gnd nfet w=10 l=2
+  ad=50p pd=30u as=0 ps=0
M4755 vdd INVX2_10/A DFFNEGX1_7/a_76_84# vdd pfet w=10 l=2
+  ad=0 pd=0 as=29.999998p ps=26u
M4756 gnd INVX2_10/A DFFNEGX1_7/a_76_6# Gnd nfet w=10 l=2
+  ad=0 pd=0 as=0 ps=0
M4757 DFFNEGX1_7/a_61_6# DFFNEGX1_7/a_34_4# gnd Gnd nfet w=10 l=2
+  ad=0 pd=0 as=0 ps=0
M4758 DFFNEGX1_7/a_76_84# DFFNEGX1_7/a_2_6# DFFNEGX1_7/a_66_6# vdd pfet w=10 l=2
+  ad=0 pd=0 as=0.15n ps=56u
M4759 INVX2_10/A DFFNEGX1_7/a_66_6# vdd vdd pfet w=40 l=2
+  ad=0.2n pd=90u as=0 ps=0
M4760 vdd BUFX2_7/Y DFFNEGX1_7/a_2_6# vdd pfet w=40 l=2
+  ad=0 pd=0 as=0.2n ps=90u
M4761 DFFNEGX1_7/a_31_6# DFFNEGX1_7/a_2_6# DFFNEGX1_7/a_23_6# Gnd nfet w=10 l=2
+  ad=0 pd=0 as=0 ps=0
M4762 DFFNEGX1_7/a_66_6# BUFX2_7/Y DFFNEGX1_7/a_61_74# vdd pfet w=20 l=2
+  ad=0 pd=0 as=0 ps=0
M4763 DFFNEGX1_7/a_17_74# NOR2X1_18/Y vdd vdd pfet w=20 l=2
+  ad=0 pd=0 as=0 ps=0
M4764 DFFNEGX1_7/a_31_74# BUFX2_7/Y DFFNEGX1_7/a_23_6# vdd pfet w=20 l=2
+  ad=0 pd=0 as=0 ps=0
M4765 DFFNEGX1_7/a_17_6# NOR2X1_18/Y gnd Gnd nfet w=10 l=2
+  ad=0 pd=0 as=0 ps=0
M4766 INVX2_119/Y HAX1_5/YS gnd Gnd nfet w=20 l=2
+  ad=100p pd=50u as=0 ps=0
M4767 INVX2_119/Y HAX1_5/YS vdd vdd pfet w=40 l=2
+  ad=0.2n pd=90u as=0 ps=0
M4768 INVX2_108/Y INVX2_108/A gnd Gnd nfet w=20 l=2
+  ad=100p pd=50u as=0 ps=0
M4769 INVX2_108/Y INVX2_108/A vdd vdd pfet w=40 l=2
+  ad=0.2n pd=90u as=0 ps=0
M4770 gnd INVX2_161/Y OAI21X1_109/a_2_6# Gnd nfet w=20 l=2
+  ad=0 pd=0 as=0.22n ps=0.102m
M4771 vdd INVX2_131/A INVX2_164/A vdd pfet w=20 l=2
+  ad=0 pd=0 as=0.22n ps=92u
M4772 INVX2_164/A INVX2_131/A OAI21X1_109/a_2_6# Gnd nfet w=20 l=2
+  ad=100p pd=50u as=0 ps=0
M4773 INVX2_164/A NOR2X1_45/Y OAI21X1_109/a_9_54# vdd pfet w=40 l=2
+  ad=0 pd=0 as=0.12n ps=86u
M4774 OAI21X1_109/a_9_54# INVX2_161/Y vdd vdd pfet w=40 l=2
+  ad=0 pd=0 as=0 ps=0
M4775 OAI21X1_109/a_2_6# NOR2X1_45/Y gnd Gnd nfet w=20 l=2
+  ad=0 pd=0 as=0 ps=0
M4776 vdd BUFX2_7/A BUFX2_7/a_2_6# vdd pfet w=20 l=2
+  ad=0 pd=0 as=100p ps=50u
M4777 gnd BUFX2_7/A BUFX2_7/a_2_6# Gnd nfet w=10 l=2
+  ad=0 pd=0 as=50p ps=30u
M4778 BUFX2_7/Y BUFX2_7/a_2_6# vdd vdd pfet w=40 l=2
+  ad=0.2n pd=90u as=0 ps=0
M4779 BUFX2_7/Y BUFX2_7/a_2_6# gnd Gnd nfet w=20 l=2
+  ad=100p pd=50u as=0 ps=0
M4780 NAND2X1_2/Y AND2X2_0/A vdd vdd pfet w=20 l=2
+  ad=0.12n pd=52u as=0 ps=0
M4781 NAND2X1_2/a_9_6# AND2X2_0/A gnd Gnd nfet w=20 l=2
+  ad=59.999996p pd=46u as=0 ps=0
M4782 vdd NOR2X1_23/B NAND2X1_2/Y vdd pfet w=20 l=2
+  ad=0 pd=0 as=0 ps=0
M4783 NAND2X1_2/Y NOR2X1_23/B NAND2X1_2/a_9_6# Gnd nfet w=20 l=2
+  ad=100p pd=50u as=0 ps=0
M4784 INVX2_7/Y invader_bullet_coord_x[0] gnd Gnd nfet w=20 l=2
+  ad=100p pd=50u as=0 ps=0
M4785 INVX2_7/Y invader_bullet_coord_x[0] vdd vdd pfet w=40 l=2
+  ad=0.2n pd=90u as=0 ps=0
M4786 AOI21X1_7/a_2_54# invader_2_coord_y[1] vdd vdd pfet w=40 l=2
+  ad=0.44n pd=0.182m as=0 ps=0
M4787 AOI21X1_7/a_12_6# invader_2_coord_y[0] gnd Gnd nfet w=20 l=2
+  ad=59.999996p pd=46u as=0 ps=0
M4788 gnd NOR2X1_8/Y INVX2_35/A Gnd nfet w=10 l=2
+  ad=0 pd=0 as=0.11n ps=52u
M4789 vdd invader_2_coord_y[0] AOI21X1_7/a_2_54# vdd pfet w=40 l=2
+  ad=0 pd=0 as=0 ps=0
M4790 INVX2_35/A NOR2X1_8/Y AOI21X1_7/a_2_54# vdd pfet w=40 l=2
+  ad=0.2n pd=90u as=0 ps=0
M4791 INVX2_35/A invader_2_coord_y[1] AOI21X1_7/a_12_6# Gnd nfet w=20 l=2
+  ad=0 pd=0 as=0 ps=0
M4792 NOR2X1_5/Y NOR2X1_5/A gnd Gnd nfet w=10 l=2
+  ad=59.999996p pd=32u as=0 ps=0
M4793 NOR2X1_5/Y invader_2_coord_x[3] NOR2X1_5/a_9_54# vdd pfet w=40 l=2
+  ad=0.2n pd=90u as=0.12n ps=86u
M4794 NOR2X1_5/a_9_54# NOR2X1_5/A vdd vdd pfet w=40 l=2
+  ad=0 pd=0 as=0 ps=0
M4795 gnd invader_2_coord_x[3] NOR2X1_5/Y Gnd nfet w=10 l=2
+  ad=0 pd=0 as=0 ps=0
M4796 AOI21X1_26/a_2_54# NOR2X1_45/Y vdd vdd pfet w=40 l=2
+  ad=0.44n pd=0.182m as=0 ps=0
M4797 AOI21X1_26/a_12_6# HAX1_5/YS gnd Gnd nfet w=20 l=2
+  ad=59.999996p pd=46u as=0 ps=0
M4798 gnd INVX2_163/Y AOI21X1_26/Y Gnd nfet w=10 l=2
+  ad=0 pd=0 as=0.11n ps=52u
M4799 vdd HAX1_5/YS AOI21X1_26/a_2_54# vdd pfet w=40 l=2
+  ad=0 pd=0 as=0 ps=0
M4800 AOI21X1_26/Y INVX2_163/Y AOI21X1_26/a_2_54# vdd pfet w=40 l=2
+  ad=0.2n pd=90u as=0 ps=0
M4801 AOI21X1_26/Y NOR2X1_45/Y AOI21X1_26/a_12_6# Gnd nfet w=20 l=2
+  ad=0 pd=0 as=0 ps=0
M4802 AOI21X1_15/a_2_54# invader_1_coord_y[1] vdd vdd pfet w=40 l=2
+  ad=0.44n pd=0.182m as=0 ps=0
M4803 AOI21X1_15/a_12_6# invader_1_coord_y[0] gnd Gnd nfet w=20 l=2
+  ad=59.999996p pd=46u as=0 ps=0
M4804 gnd NOR2X1_12/Y INVX2_73/A Gnd nfet w=10 l=2
+  ad=0 pd=0 as=0.11n ps=52u
M4805 vdd invader_1_coord_y[0] AOI21X1_15/a_2_54# vdd pfet w=40 l=2
+  ad=0 pd=0 as=0 ps=0
M4806 INVX2_73/A NOR2X1_12/Y AOI21X1_15/a_2_54# vdd pfet w=40 l=2
+  ad=0.2n pd=90u as=0 ps=0
M4807 INVX2_73/A invader_1_coord_y[1] AOI21X1_15/a_12_6# Gnd nfet w=20 l=2
+  ad=0 pd=0 as=0 ps=0
M4808 OR2X1_2/a_2_54# OR2X1_2/A gnd Gnd nfet w=10 l=2
+  ad=59.999996p pd=32u as=0 ps=0
M4809 OR2X1_2/Y OR2X1_2/a_2_54# vdd vdd pfet w=20 l=2
+  ad=100p pd=50u as=0 ps=0
M4810 OR2X1_2/Y OR2X1_2/a_2_54# gnd Gnd nfet w=10 l=2
+  ad=50p pd=30u as=0 ps=0
M4811 vdd OR2X1_2/B OR2X1_2/a_9_54# vdd pfet w=40 l=2
+  ad=0 pd=0 as=0.12n ps=86u
M4812 OR2X1_2/a_9_54# OR2X1_2/A OR2X1_2/a_2_54# vdd pfet w=40 l=2
+  ad=0 pd=0 as=0.2n ps=90u
M4813 gnd OR2X1_2/B OR2X1_2/a_2_54# Gnd nfet w=10 l=2
+  ad=0 pd=0 as=0 ps=0
M4814 DFFNEGX1_8/a_76_6# BUFX2_7/Y DFFNEGX1_8/a_66_6# Gnd nfet w=10 l=2
+  ad=29.999998p pd=26u as=80p ps=36u
M4815 gnd BUFX2_7/Y DFFNEGX1_8/a_2_6# Gnd nfet w=20 l=2
+  ad=0 pd=0 as=100p ps=50u
M4816 DFFNEGX1_8/a_66_6# DFFNEGX1_8/a_2_6# DFFNEGX1_8/a_61_6# Gnd nfet w=10 l=2
+  ad=0 pd=0 as=29.999998p ps=26u
M4817 invader_bullet_display DFFNEGX1_8/a_66_6# gnd Gnd nfet w=20 l=2
+  ad=100p pd=50u as=0 ps=0
M4818 DFFNEGX1_8/a_23_6# BUFX2_7/Y DFFNEGX1_8/a_17_6# Gnd nfet w=10 l=2
+  ad=59.999996p pd=32u as=40p ps=28u
M4819 DFFNEGX1_8/a_23_6# DFFNEGX1_8/a_2_6# DFFNEGX1_8/a_17_74# vdd pfet w=20 l=2
+  ad=0.12n pd=52u as=80p ps=48u
M4820 gnd DFFNEGX1_8/a_34_4# DFFNEGX1_8/a_31_6# Gnd nfet w=10 l=2
+  ad=0 pd=0 as=29.999998p ps=26u
M4821 vdd DFFNEGX1_8/a_34_4# DFFNEGX1_8/a_31_74# vdd pfet w=20 l=2
+  ad=0 pd=0 as=80p ps=48u
M4822 DFFNEGX1_8/a_61_74# DFFNEGX1_8/a_34_4# vdd vdd pfet w=20 l=2
+  ad=59.999996p pd=46u as=0 ps=0
M4823 DFFNEGX1_8/a_34_4# DFFNEGX1_8/a_23_6# vdd vdd pfet w=20 l=2
+  ad=100p pd=50u as=0 ps=0
M4824 DFFNEGX1_8/a_34_4# DFFNEGX1_8/a_23_6# gnd Gnd nfet w=10 l=2
+  ad=50p pd=30u as=0 ps=0
M4825 vdd invader_bullet_display DFFNEGX1_8/a_76_84# vdd pfet w=10 l=2
+  ad=0 pd=0 as=29.999998p ps=26u
M4826 gnd invader_bullet_display DFFNEGX1_8/a_76_6# Gnd nfet w=10 l=2
+  ad=0 pd=0 as=0 ps=0
M4827 DFFNEGX1_8/a_61_6# DFFNEGX1_8/a_34_4# gnd Gnd nfet w=10 l=2
+  ad=0 pd=0 as=0 ps=0
M4828 DFFNEGX1_8/a_76_84# DFFNEGX1_8/a_2_6# DFFNEGX1_8/a_66_6# vdd pfet w=10 l=2
+  ad=0 pd=0 as=0.15n ps=56u
M4829 invader_bullet_display DFFNEGX1_8/a_66_6# vdd vdd pfet w=40 l=2
+  ad=0.2n pd=90u as=0 ps=0
M4830 vdd BUFX2_7/Y DFFNEGX1_8/a_2_6# vdd pfet w=40 l=2
+  ad=0 pd=0 as=0.2n ps=90u
M4831 DFFNEGX1_8/a_31_6# DFFNEGX1_8/a_2_6# DFFNEGX1_8/a_23_6# Gnd nfet w=10 l=2
+  ad=0 pd=0 as=0 ps=0
M4832 DFFNEGX1_8/a_66_6# BUFX2_7/Y DFFNEGX1_8/a_61_74# vdd pfet w=20 l=2
+  ad=0 pd=0 as=0 ps=0
M4833 DFFNEGX1_8/a_17_74# NOR2X1_0/Y vdd vdd pfet w=20 l=2
+  ad=0 pd=0 as=0 ps=0
M4834 DFFNEGX1_8/a_31_74# BUFX2_7/Y DFFNEGX1_8/a_23_6# vdd pfet w=20 l=2
+  ad=0 pd=0 as=0 ps=0
M4835 DFFNEGX1_8/a_17_6# NOR2X1_0/Y gnd Gnd nfet w=10 l=2
+  ad=0 pd=0 as=0 ps=0
M4836 INVX2_109/Y INVX2_109/A gnd Gnd nfet w=20 l=2
+  ad=100p pd=50u as=0 ps=0
M4837 INVX2_109/Y INVX2_109/A vdd vdd pfet w=40 l=2
+  ad=0.2n pd=90u as=0 ps=0
M4838 NAND2X1_3/Y NAND2X1_3/A vdd vdd pfet w=20 l=2
+  ad=0.12n pd=52u as=0 ps=0
M4839 NAND2X1_3/a_9_6# NAND2X1_3/A gnd Gnd nfet w=20 l=2
+  ad=59.999996p pd=46u as=0 ps=0
M4840 vdd NAND2X1_4/Y NAND2X1_3/Y vdd pfet w=20 l=2
+  ad=0 pd=0 as=0 ps=0
M4841 NAND2X1_3/Y NAND2X1_4/Y NAND2X1_3/a_9_6# Gnd nfet w=20 l=2
+  ad=100p pd=50u as=0 ps=0
M4842 INVX2_8/Y INVX2_8/A gnd Gnd nfet w=20 l=2
+  ad=100p pd=50u as=0 ps=0
M4843 INVX2_8/Y INVX2_8/A vdd vdd pfet w=40 l=2
+  ad=0.2n pd=90u as=0 ps=0
M4844 AOI21X1_8/a_2_54# AOI21X1_8/B vdd vdd pfet w=40 l=2
+  ad=0.44n pd=0.182m as=0 ps=0
M4845 AOI21X1_8/a_12_6# INVX2_42/Y gnd Gnd nfet w=20 l=2
+  ad=59.999996p pd=46u as=0 ps=0
M4846 gnd AOI21X1_8/C AOI21X1_8/Y Gnd nfet w=10 l=2
+  ad=0 pd=0 as=0.11n ps=52u
M4847 vdd INVX2_42/Y AOI21X1_8/a_2_54# vdd pfet w=40 l=2
+  ad=0 pd=0 as=0 ps=0
M4848 AOI21X1_8/Y AOI21X1_8/C AOI21X1_8/a_2_54# vdd pfet w=40 l=2
+  ad=0.2n pd=90u as=0 ps=0
M4849 AOI21X1_8/Y AOI21X1_8/B AOI21X1_8/a_12_6# Gnd nfet w=20 l=2
+  ad=0 pd=0 as=0 ps=0
M4850 NOR2X1_6/Y invader_2_coord_x[1] gnd Gnd nfet w=10 l=2
+  ad=59.999996p pd=32u as=0 ps=0
M4851 NOR2X1_6/Y invader_2_coord_x[0] NOR2X1_6/a_9_54# vdd pfet w=40 l=2
+  ad=0.2n pd=90u as=0.12n ps=86u
M4852 NOR2X1_6/a_9_54# invader_2_coord_x[1] vdd vdd pfet w=40 l=2
+  ad=0 pd=0 as=0 ps=0
M4853 gnd invader_2_coord_x[0] NOR2X1_6/Y Gnd nfet w=10 l=2
+  ad=0 pd=0 as=0 ps=0
M4854 AOI21X1_16/a_2_54# OAI21X1_26/Y vdd vdd pfet w=40 l=2
+  ad=0.44n pd=0.182m as=0 ps=0
M4855 AOI21X1_16/a_12_6# INVX2_80/Y gnd Gnd nfet w=20 l=2
+  ad=59.999996p pd=46u as=0 ps=0
M4856 gnd OAI21X1_24/Y NAND3X1_35/A Gnd nfet w=10 l=2
+  ad=0 pd=0 as=0.11n ps=52u
M4857 vdd INVX2_80/Y AOI21X1_16/a_2_54# vdd pfet w=40 l=2
+  ad=0 pd=0 as=0 ps=0
M4858 NAND3X1_35/A OAI21X1_24/Y AOI21X1_16/a_2_54# vdd pfet w=40 l=2
+  ad=0.2n pd=90u as=0 ps=0
M4859 NAND3X1_35/A OAI21X1_26/Y AOI21X1_16/a_12_6# Gnd nfet w=20 l=2
+  ad=0 pd=0 as=0 ps=0
M4860 AOI21X1_27/a_2_54# OR2X1_15/A vdd vdd pfet w=40 l=2
+  ad=0.44n pd=0.182m as=0 ps=0
M4861 AOI21X1_27/a_12_6# NOR2X1_54/Y gnd Gnd nfet w=20 l=2
+  ad=59.999996p pd=46u as=0 ps=0
M4862 gnd OR2X1_18/A INVX2_167/A Gnd nfet w=10 l=2
+  ad=0 pd=0 as=0.11n ps=52u
M4863 vdd NOR2X1_54/Y AOI21X1_27/a_2_54# vdd pfet w=40 l=2
+  ad=0 pd=0 as=0 ps=0
M4864 INVX2_167/A OR2X1_18/A AOI21X1_27/a_2_54# vdd pfet w=40 l=2
+  ad=0.2n pd=90u as=0 ps=0
M4865 INVX2_167/A OR2X1_15/A AOI21X1_27/a_12_6# Gnd nfet w=20 l=2
+  ad=0 pd=0 as=0 ps=0
M4866 OR2X1_3/a_2_54# OR2X1_3/A gnd Gnd nfet w=10 l=2
+  ad=59.999996p pd=32u as=0 ps=0
M4867 OR2X1_3/Y OR2X1_3/a_2_54# vdd vdd pfet w=20 l=2
+  ad=100p pd=50u as=0 ps=0
M4868 OR2X1_3/Y OR2X1_3/a_2_54# gnd Gnd nfet w=10 l=2
+  ad=50p pd=30u as=0 ps=0
M4869 vdd OR2X1_3/B OR2X1_3/a_9_54# vdd pfet w=40 l=2
+  ad=0 pd=0 as=0.12n ps=86u
M4870 OR2X1_3/a_9_54# OR2X1_3/A OR2X1_3/a_2_54# vdd pfet w=40 l=2
+  ad=0 pd=0 as=0.2n ps=90u
M4871 gnd OR2X1_3/B OR2X1_3/a_2_54# Gnd nfet w=10 l=2
+  ad=0 pd=0 as=0 ps=0
M4872 DFFNEGX1_9/a_76_6# BUFX2_7/Y DFFNEGX1_9/a_66_6# Gnd nfet w=10 l=2
+  ad=29.999998p pd=26u as=80p ps=36u
M4873 gnd BUFX2_7/Y DFFNEGX1_9/a_2_6# Gnd nfet w=20 l=2
+  ad=0 pd=0 as=100p ps=50u
M4874 DFFNEGX1_9/a_66_6# DFFNEGX1_9/a_2_6# DFFNEGX1_9/a_61_6# Gnd nfet w=10 l=2
+  ad=0 pd=0 as=29.999998p ps=26u
M4875 invader_bullet_coord_y[1] DFFNEGX1_9/a_66_6# gnd Gnd nfet w=20 l=2
+  ad=100p pd=50u as=0 ps=0
M4876 DFFNEGX1_9/a_23_6# BUFX2_7/Y DFFNEGX1_9/a_17_6# Gnd nfet w=10 l=2
+  ad=59.999996p pd=32u as=40p ps=28u
M4877 DFFNEGX1_9/a_23_6# DFFNEGX1_9/a_2_6# DFFNEGX1_9/a_17_74# vdd pfet w=20 l=2
+  ad=0.12n pd=52u as=80p ps=48u
M4878 gnd DFFNEGX1_9/a_34_4# DFFNEGX1_9/a_31_6# Gnd nfet w=10 l=2
+  ad=0 pd=0 as=29.999998p ps=26u
M4879 vdd DFFNEGX1_9/a_34_4# DFFNEGX1_9/a_31_74# vdd pfet w=20 l=2
+  ad=0 pd=0 as=80p ps=48u
M4880 DFFNEGX1_9/a_61_74# DFFNEGX1_9/a_34_4# vdd vdd pfet w=20 l=2
+  ad=59.999996p pd=46u as=0 ps=0
M4881 DFFNEGX1_9/a_34_4# DFFNEGX1_9/a_23_6# vdd vdd pfet w=20 l=2
+  ad=100p pd=50u as=0 ps=0
M4882 DFFNEGX1_9/a_34_4# DFFNEGX1_9/a_23_6# gnd Gnd nfet w=10 l=2
+  ad=50p pd=30u as=0 ps=0
M4883 vdd invader_bullet_coord_y[1] DFFNEGX1_9/a_76_84# vdd pfet w=10 l=2
+  ad=0 pd=0 as=29.999998p ps=26u
M4884 gnd invader_bullet_coord_y[1] DFFNEGX1_9/a_76_6# Gnd nfet w=10 l=2
+  ad=0 pd=0 as=0 ps=0
M4885 DFFNEGX1_9/a_61_6# DFFNEGX1_9/a_34_4# gnd Gnd nfet w=10 l=2
+  ad=0 pd=0 as=0 ps=0
M4886 DFFNEGX1_9/a_76_84# DFFNEGX1_9/a_2_6# DFFNEGX1_9/a_66_6# vdd pfet w=10 l=2
+  ad=0 pd=0 as=0.15n ps=56u
M4887 invader_bullet_coord_y[1] DFFNEGX1_9/a_66_6# vdd vdd pfet w=40 l=2
+  ad=0.2n pd=90u as=0 ps=0
M4888 vdd BUFX2_7/Y DFFNEGX1_9/a_2_6# vdd pfet w=40 l=2
+  ad=0 pd=0 as=0.2n ps=90u
M4889 DFFNEGX1_9/a_31_6# DFFNEGX1_9/a_2_6# DFFNEGX1_9/a_23_6# Gnd nfet w=10 l=2
+  ad=0 pd=0 as=0 ps=0
M4890 DFFNEGX1_9/a_66_6# BUFX2_7/Y DFFNEGX1_9/a_61_74# vdd pfet w=20 l=2
+  ad=0 pd=0 as=0 ps=0
M4891 DFFNEGX1_9/a_17_74# NOR2X1_1/Y vdd vdd pfet w=20 l=2
+  ad=0 pd=0 as=0 ps=0
M4892 DFFNEGX1_9/a_31_74# BUFX2_7/Y DFFNEGX1_9/a_23_6# vdd pfet w=20 l=2
+  ad=0 pd=0 as=0 ps=0
M4893 DFFNEGX1_9/a_17_6# NOR2X1_1/Y gnd Gnd nfet w=10 l=2
+  ad=0 pd=0 as=0 ps=0
M4894 gnd OAI21X1_91/B OAI21X1_90/a_2_6# Gnd nfet w=20 l=2
+  ad=0 pd=0 as=0.22n ps=0.102m
M4895 vdd OAI21X1_90/C OAI21X1_90/Y vdd pfet w=20 l=2
+  ad=0 pd=0 as=0.22n ps=92u
M4896 OAI21X1_90/Y OAI21X1_90/C OAI21X1_90/a_2_6# Gnd nfet w=20 l=2
+  ad=100p pd=50u as=0 ps=0
M4897 OAI21X1_90/Y INVX2_82/A OAI21X1_90/a_9_54# vdd pfet w=40 l=2
+  ad=0 pd=0 as=0.12n ps=86u
M4898 OAI21X1_90/a_9_54# OAI21X1_91/B vdd vdd pfet w=40 l=2
+  ad=0 pd=0 as=0 ps=0
M4899 OAI21X1_90/a_2_6# INVX2_82/A gnd Gnd nfet w=20 l=2
+  ad=0 pd=0 as=0 ps=0
M4900 NOR2X1_60/Y NOR2X1_60/A gnd Gnd nfet w=10 l=2
+  ad=59.999996p pd=32u as=0 ps=0
M4901 NOR2X1_60/Y NOR2X1_60/B NOR2X1_60/a_9_54# vdd pfet w=40 l=2
+  ad=0.2n pd=90u as=0.12n ps=86u
M4902 NOR2X1_60/a_9_54# NOR2X1_60/A vdd vdd pfet w=40 l=2
+  ad=0 pd=0 as=0 ps=0
M4903 gnd NOR2X1_60/B NOR2X1_60/Y Gnd nfet w=10 l=2
+  ad=0 pd=0 as=0 ps=0
M4904 NAND2X1_4/Y NOR2X1_25/Y vdd vdd pfet w=20 l=2
+  ad=0.12n pd=52u as=0 ps=0
M4905 NAND2X1_4/a_9_6# NOR2X1_25/Y gnd Gnd nfet w=20 l=2
+  ad=59.999996p pd=46u as=0 ps=0
M4906 vdd player_bullet_coord_y[1] NAND2X1_4/Y vdd pfet w=20 l=2
+  ad=0 pd=0 as=0 ps=0
M4907 NAND2X1_4/Y player_bullet_coord_y[1] NAND2X1_4/a_9_6# Gnd nfet w=20 l=2
+  ad=100p pd=50u as=0 ps=0
M4908 INVX2_9/Y INVX2_9/A gnd Gnd nfet w=20 l=2
+  ad=100p pd=50u as=0 ps=0
M4909 INVX2_9/Y INVX2_9/A vdd vdd pfet w=40 l=2
+  ad=0.2n pd=90u as=0 ps=0
M4910 AOI21X1_9/a_2_54# invader_1_coord_x[3] vdd vdd pfet w=40 l=2
+  ad=0.44n pd=0.182m as=0 ps=0
M4911 AOI21X1_9/a_12_6# NOR2X1_9/A gnd Gnd nfet w=20 l=2
+  ad=59.999996p pd=46u as=0 ps=0
M4912 gnd NOR2X1_9/Y INVX2_68/A Gnd nfet w=10 l=2
+  ad=0 pd=0 as=0.11n ps=52u
M4913 vdd NOR2X1_9/A AOI21X1_9/a_2_54# vdd pfet w=40 l=2
+  ad=0 pd=0 as=0 ps=0
M4914 INVX2_68/A NOR2X1_9/Y AOI21X1_9/a_2_54# vdd pfet w=40 l=2
+  ad=0.2n pd=90u as=0 ps=0
M4915 INVX2_68/A invader_1_coord_x[3] AOI21X1_9/a_12_6# Gnd nfet w=20 l=2
+  ad=0 pd=0 as=0 ps=0
M4916 NOR2X1_7/Y NOR2X1_7/A gnd Gnd nfet w=10 l=2
+  ad=59.999996p pd=32u as=0 ps=0
M4917 NOR2X1_7/Y invader_2_coord_y[3] NOR2X1_7/a_9_54# vdd pfet w=40 l=2
+  ad=0.2n pd=90u as=0.12n ps=86u
M4918 NOR2X1_7/a_9_54# NOR2X1_7/A vdd vdd pfet w=40 l=2
+  ad=0 pd=0 as=0 ps=0
M4919 gnd invader_2_coord_y[3] NOR2X1_7/Y Gnd nfet w=10 l=2
+  ad=0 pd=0 as=0 ps=0
M4920 AOI21X1_17/a_2_54# INVX2_4/Y vdd vdd pfet w=40 l=2
+  ad=0.44n pd=0.182m as=0 ps=0
M4921 AOI21X1_17/a_12_6# XOR2X1_4/Y gnd Gnd nfet w=20 l=2
+  ad=59.999996p pd=46u as=0 ps=0
M4922 gnd INVX2_93/Y AOI22X1_8/C Gnd nfet w=10 l=2
+  ad=0 pd=0 as=0.11n ps=52u
M4923 vdd XOR2X1_4/Y AOI21X1_17/a_2_54# vdd pfet w=40 l=2
+  ad=0 pd=0 as=0 ps=0
M4924 AOI22X1_8/C INVX2_93/Y AOI21X1_17/a_2_54# vdd pfet w=40 l=2
+  ad=0.2n pd=90u as=0 ps=0
M4925 AOI22X1_8/C INVX2_4/Y AOI21X1_17/a_12_6# Gnd nfet w=20 l=2
+  ad=0 pd=0 as=0 ps=0
M4926 AOI21X1_28/a_2_54# INVX2_165/Y vdd vdd pfet w=40 l=2
+  ad=0.44n pd=0.182m as=0 ps=0
M4927 AOI21X1_28/a_12_6# INVX2_127/Y gnd Gnd nfet w=20 l=2
+  ad=59.999996p pd=46u as=0 ps=0
M4928 gnd NOR2X1_54/Y AOI21X1_28/Y Gnd nfet w=10 l=2
+  ad=0 pd=0 as=0.11n ps=52u
M4929 vdd INVX2_127/Y AOI21X1_28/a_2_54# vdd pfet w=40 l=2
+  ad=0 pd=0 as=0 ps=0
M4930 AOI21X1_28/Y NOR2X1_54/Y AOI21X1_28/a_2_54# vdd pfet w=40 l=2
+  ad=0.2n pd=90u as=0 ps=0
M4931 AOI21X1_28/Y INVX2_165/Y AOI21X1_28/a_12_6# Gnd nfet w=20 l=2
+  ad=0 pd=0 as=0 ps=0
M4932 OR2X1_4/a_2_54# OR2X1_4/A gnd Gnd nfet w=10 l=2
+  ad=59.999996p pd=32u as=0 ps=0
M4933 OR2X1_4/Y OR2X1_4/a_2_54# vdd vdd pfet w=20 l=2
+  ad=100p pd=50u as=0 ps=0
M4934 OR2X1_4/Y OR2X1_4/a_2_54# gnd Gnd nfet w=10 l=2
+  ad=50p pd=30u as=0 ps=0
M4935 vdd OR2X1_4/B OR2X1_4/a_9_54# vdd pfet w=40 l=2
+  ad=0 pd=0 as=0.12n ps=86u
M4936 OR2X1_4/a_9_54# OR2X1_4/A OR2X1_4/a_2_54# vdd pfet w=40 l=2
+  ad=0 pd=0 as=0.2n ps=90u
M4937 gnd OR2X1_4/B OR2X1_4/a_2_54# Gnd nfet w=10 l=2
+  ad=0 pd=0 as=0 ps=0
M4938 gnd AND2X2_14/B OAI21X1_80/a_2_6# Gnd nfet w=20 l=2
+  ad=0 pd=0 as=0.22n ps=0.102m
M4939 vdd OAI21X1_80/C OAI21X1_80/Y vdd pfet w=20 l=2
+  ad=0 pd=0 as=0.22n ps=92u
M4940 OAI21X1_80/Y OAI21X1_80/C OAI21X1_80/a_2_6# Gnd nfet w=20 l=2
+  ad=100p pd=50u as=0 ps=0
M4941 OAI21X1_80/Y OAI22X1_7/C OAI21X1_80/a_9_54# vdd pfet w=40 l=2
+  ad=0 pd=0 as=0.12n ps=86u
M4942 OAI21X1_80/a_9_54# AND2X2_14/B vdd vdd pfet w=40 l=2
+  ad=0 pd=0 as=0 ps=0
M4943 OAI21X1_80/a_2_6# OAI22X1_7/C gnd Gnd nfet w=20 l=2
+  ad=0 pd=0 as=0 ps=0
M4944 gnd INVX2_82/Y OAI21X1_91/a_2_6# Gnd nfet w=20 l=2
+  ad=0 pd=0 as=0.22n ps=0.102m
M4945 vdd OAI21X1_91/C OAI21X1_91/Y vdd pfet w=20 l=2
+  ad=0 pd=0 as=0.22n ps=92u
M4946 OAI21X1_91/Y OAI21X1_91/C OAI21X1_91/a_2_6# Gnd nfet w=20 l=2
+  ad=100p pd=50u as=0 ps=0
M4947 OAI21X1_91/Y OAI21X1_91/B OAI21X1_91/a_9_54# vdd pfet w=40 l=2
+  ad=0 pd=0 as=0.12n ps=86u
M4948 OAI21X1_91/a_9_54# INVX2_82/Y vdd vdd pfet w=40 l=2
+  ad=0 pd=0 as=0 ps=0
M4949 OAI21X1_91/a_2_6# OAI21X1_91/B gnd Gnd nfet w=20 l=2
+  ad=0 pd=0 as=0 ps=0
M4950 NOR2X1_50/Y OR2X1_15/B gnd Gnd nfet w=10 l=2
+  ad=59.999996p pd=32u as=0 ps=0
M4951 NOR2X1_50/Y OR2X1_16/Y NOR2X1_50/a_9_54# vdd pfet w=40 l=2
+  ad=0.2n pd=90u as=0.12n ps=86u
M4952 NOR2X1_50/a_9_54# OR2X1_15/B vdd vdd pfet w=40 l=2
+  ad=0 pd=0 as=0 ps=0
M4953 gnd OR2X1_16/Y NOR2X1_50/Y Gnd nfet w=10 l=2
+  ad=0 pd=0 as=0 ps=0
M4954 NOR2X1_4/B INVX2_12/Y vdd vdd pfet w=20 l=2
+  ad=0.12n pd=52u as=0 ps=0
M4955 NAND2X1_5/a_9_6# INVX2_12/Y gnd Gnd nfet w=20 l=2
+  ad=59.999996p pd=46u as=0 ps=0
M4956 vdd NAND2X1_5/B NOR2X1_4/B vdd pfet w=20 l=2
+  ad=0 pd=0 as=0 ps=0
M4957 NOR2X1_4/B NAND2X1_5/B NAND2X1_5/a_9_6# Gnd nfet w=20 l=2
+  ad=100p pd=50u as=0 ps=0
M4958 NOR2X1_8/Y invader_2_coord_y[1] gnd Gnd nfet w=10 l=2
+  ad=59.999996p pd=32u as=0 ps=0
M4959 NOR2X1_8/Y invader_2_coord_y[0] NOR2X1_8/a_9_54# vdd pfet w=40 l=2
+  ad=0.2n pd=90u as=0.12n ps=86u
M4960 NOR2X1_8/a_9_54# invader_2_coord_y[1] vdd vdd pfet w=40 l=2
+  ad=0 pd=0 as=0 ps=0
M4961 gnd invader_2_coord_y[0] NOR2X1_8/Y Gnd nfet w=10 l=2
+  ad=0 pd=0 as=0 ps=0
M4962 AOI21X1_29/a_2_54# NAND3X1_46/Y vdd vdd pfet w=40 l=2
+  ad=0.44n pd=0.182m as=0 ps=0
M4963 AOI21X1_29/a_12_6# NAND2X1_64/Y gnd Gnd nfet w=20 l=2
+  ad=59.999996p pd=46u as=0 ps=0
M4964 gnd reset AOI21X1_29/Y Gnd nfet w=10 l=2
+  ad=0 pd=0 as=0.11n ps=52u
M4965 vdd NAND2X1_64/Y AOI21X1_29/a_2_54# vdd pfet w=40 l=2
+  ad=0 pd=0 as=0 ps=0
M4966 AOI21X1_29/Y reset AOI21X1_29/a_2_54# vdd pfet w=40 l=2
+  ad=0.2n pd=90u as=0 ps=0
M4967 AOI21X1_29/Y NAND3X1_46/Y AOI21X1_29/a_12_6# Gnd nfet w=20 l=2
+  ad=0 pd=0 as=0 ps=0
M4968 AOI21X1_18/a_2_54# INVX2_19/Y vdd vdd pfet w=40 l=2
+  ad=0.44n pd=0.182m as=0 ps=0
M4969 AOI21X1_18/a_12_6# XOR2X1_4/Y gnd Gnd nfet w=20 l=2
+  ad=59.999996p pd=46u as=0 ps=0
M4970 gnd INVX2_93/Y AOI22X1_11/C Gnd nfet w=10 l=2
+  ad=0 pd=0 as=0.11n ps=52u
M4971 vdd XOR2X1_4/Y AOI21X1_18/a_2_54# vdd pfet w=40 l=2
+  ad=0 pd=0 as=0 ps=0
M4972 AOI22X1_11/C INVX2_93/Y AOI21X1_18/a_2_54# vdd pfet w=40 l=2
+  ad=0.2n pd=90u as=0 ps=0
M4973 AOI22X1_11/C INVX2_19/Y AOI21X1_18/a_12_6# Gnd nfet w=20 l=2
+  ad=0 pd=0 as=0 ps=0
M4974 OR2X1_5/a_2_54# OR2X1_5/A gnd Gnd nfet w=10 l=2
+  ad=59.999996p pd=32u as=0 ps=0
M4975 OR2X1_5/Y OR2X1_5/a_2_54# vdd vdd pfet w=20 l=2
+  ad=100p pd=50u as=0 ps=0
M4976 OR2X1_5/Y OR2X1_5/a_2_54# gnd Gnd nfet w=10 l=2
+  ad=50p pd=30u as=0 ps=0
M4977 vdd OR2X1_5/B OR2X1_5/a_9_54# vdd pfet w=40 l=2
+  ad=0 pd=0 as=0.12n ps=86u
M4978 OR2X1_5/a_9_54# OR2X1_5/A OR2X1_5/a_2_54# vdd pfet w=40 l=2
+  ad=0 pd=0 as=0.2n ps=90u
M4979 gnd OR2X1_5/B OR2X1_5/a_2_54# Gnd nfet w=10 l=2
+  ad=0 pd=0 as=0 ps=0
M4980 gnd OAI21X1_81/A OAI21X1_81/a_2_6# Gnd nfet w=20 l=2
+  ad=0 pd=0 as=0.22n ps=0.102m
M4981 vdd invader_1_coord_y[3] OAI21X1_81/Y vdd pfet w=20 l=2
+  ad=0 pd=0 as=0.22n ps=92u
M4982 OAI21X1_81/Y invader_1_coord_y[3] OAI21X1_81/a_2_6# Gnd nfet w=20 l=2
+  ad=100p pd=50u as=0 ps=0
M4983 OAI21X1_81/Y INVX2_146/Y OAI21X1_81/a_9_54# vdd pfet w=40 l=2
+  ad=0 pd=0 as=0.12n ps=86u
M4984 OAI21X1_81/a_9_54# OAI21X1_81/A vdd vdd pfet w=40 l=2
+  ad=0 pd=0 as=0 ps=0
M4985 OAI21X1_81/a_2_6# INVX2_146/Y gnd Gnd nfet w=20 l=2
+  ad=0 pd=0 as=0 ps=0
M4986 gnd OAI21X1_71/B OAI21X1_70/a_2_6# Gnd nfet w=20 l=2
+  ad=0 pd=0 as=0.22n ps=0.102m
M4987 vdd OAI21X1_70/C OAI21X1_70/Y vdd pfet w=20 l=2
+  ad=0 pd=0 as=0.22n ps=92u
M4988 OAI21X1_70/Y OAI21X1_70/C OAI21X1_70/a_2_6# Gnd nfet w=20 l=2
+  ad=100p pd=50u as=0 ps=0
M4989 OAI21X1_70/Y INVX2_53/A OAI21X1_70/a_9_54# vdd pfet w=40 l=2
+  ad=0 pd=0 as=0.12n ps=86u
M4990 OAI21X1_70/a_9_54# OAI21X1_71/B vdd vdd pfet w=40 l=2
+  ad=0 pd=0 as=0 ps=0
M4991 OAI21X1_70/a_2_6# INVX2_53/A gnd Gnd nfet w=20 l=2
+  ad=0 pd=0 as=0 ps=0
M4992 gnd OAI21X1_92/A OAI21X1_92/a_2_6# Gnd nfet w=20 l=2
+  ad=0 pd=0 as=0.22n ps=0.102m
M4993 vdd OAI21X1_92/C OAI21X1_92/Y vdd pfet w=20 l=2
+  ad=0 pd=0 as=0.22n ps=92u
M4994 OAI21X1_92/Y OAI21X1_92/C OAI21X1_92/a_2_6# Gnd nfet w=20 l=2
+  ad=100p pd=50u as=0 ps=0
M4995 OAI21X1_92/Y OAI21X1_92/B OAI21X1_92/a_9_54# vdd pfet w=40 l=2
+  ad=0 pd=0 as=0.12n ps=86u
M4996 OAI21X1_92/a_9_54# OAI21X1_92/A vdd vdd pfet w=40 l=2
+  ad=0 pd=0 as=0 ps=0
M4997 OAI21X1_92/a_2_6# OAI21X1_92/B gnd Gnd nfet w=20 l=2
+  ad=0 pd=0 as=0 ps=0
M4998 OR2X1_13/B XOR2X1_12/Y vdd vdd pfet w=20 l=2
+  ad=0.22n pd=0.102m as=0 ps=0
M4999 NAND3X1_40/a_9_6# XOR2X1_12/Y gnd Gnd nfet w=30 l=2
+  ad=90p pd=66u as=0 ps=0
M5000 OR2X1_13/B XOR2X1_11/Y vdd vdd pfet w=20 l=2
+  ad=0 pd=0 as=0 ps=0
M5001 OR2X1_13/B XOR2X1_11/Y NAND3X1_40/a_14_6# Gnd nfet w=30 l=2
+  ad=0.15n pd=70u as=90p ps=66u
M5002 vdd INVX2_11/Y OR2X1_13/B vdd pfet w=20 l=2
+  ad=0 pd=0 as=0 ps=0
M5003 NAND3X1_40/a_14_6# INVX2_11/Y NAND3X1_40/a_9_6# Gnd nfet w=30 l=2
+  ad=0 pd=0 as=0 ps=0
M5004 NOR2X1_51/Y NOR2X1_51/A gnd Gnd nfet w=10 l=2
+  ad=59.999996p pd=32u as=0 ps=0
M5005 NOR2X1_51/Y OR2X1_15/Y NOR2X1_51/a_9_54# vdd pfet w=40 l=2
+  ad=0.2n pd=90u as=0.12n ps=86u
M5006 NOR2X1_51/a_9_54# NOR2X1_51/A vdd vdd pfet w=40 l=2
+  ad=0 pd=0 as=0 ps=0
M5007 gnd OR2X1_15/Y NOR2X1_51/Y Gnd nfet w=10 l=2
+  ad=0 pd=0 as=0 ps=0
M5008 NOR2X1_40/Y OR2X1_15/A gnd Gnd nfet w=10 l=2
+  ad=59.999996p pd=32u as=0 ps=0
M5009 NOR2X1_40/Y NOR2X1_40/B NOR2X1_40/a_9_54# vdd pfet w=40 l=2
+  ad=0.2n pd=90u as=0.12n ps=86u
M5010 NOR2X1_40/a_9_54# OR2X1_15/A vdd vdd pfet w=40 l=2
+  ad=0 pd=0 as=0 ps=0
M5011 gnd NOR2X1_40/B NOR2X1_40/Y Gnd nfet w=10 l=2
+  ad=0 pd=0 as=0 ps=0
M5012 NOR2X1_3/A INVX2_14/Y vdd vdd pfet w=20 l=2
+  ad=0.12n pd=52u as=0 ps=0
M5013 NAND2X1_6/a_9_6# INVX2_14/Y gnd Gnd nfet w=20 l=2
+  ad=59.999996p pd=46u as=0 ps=0
M5014 vdd INVX2_16/A NOR2X1_3/A vdd pfet w=20 l=2
+  ad=0 pd=0 as=0 ps=0
M5015 NOR2X1_3/A INVX2_16/A NAND2X1_6/a_9_6# Gnd nfet w=20 l=2
+  ad=100p pd=50u as=0 ps=0
M5016 NOR2X1_9/Y NOR2X1_9/A gnd Gnd nfet w=10 l=2
+  ad=59.999996p pd=32u as=0 ps=0
M5017 NOR2X1_9/Y invader_1_coord_x[3] NOR2X1_9/a_9_54# vdd pfet w=40 l=2
+  ad=0.2n pd=90u as=0.12n ps=86u
M5018 NOR2X1_9/a_9_54# NOR2X1_9/A vdd vdd pfet w=40 l=2
+  ad=0 pd=0 as=0 ps=0
M5019 gnd invader_1_coord_x[3] NOR2X1_9/Y Gnd nfet w=10 l=2
+  ad=0 pd=0 as=0 ps=0
M5020 AOI21X1_19/a_2_54# INVX2_3/Y vdd vdd pfet w=40 l=2
+  ad=0.44n pd=0.182m as=0 ps=0
M5021 AOI21X1_19/a_12_6# HAX1_5/YS gnd Gnd nfet w=20 l=2
+  ad=59.999996p pd=46u as=0 ps=0
M5022 gnd AOI22X1_15/Y AOI22X1_14/A Gnd nfet w=10 l=2
+  ad=0 pd=0 as=0.11n ps=52u
M5023 vdd HAX1_5/YS AOI21X1_19/a_2_54# vdd pfet w=40 l=2
+  ad=0 pd=0 as=0 ps=0
M5024 AOI22X1_14/A AOI22X1_15/Y AOI21X1_19/a_2_54# vdd pfet w=40 l=2
+  ad=0.2n pd=90u as=0 ps=0
M5025 AOI22X1_14/A INVX2_3/Y AOI21X1_19/a_12_6# Gnd nfet w=20 l=2
+  ad=0 pd=0 as=0 ps=0
M5026 OR2X1_6/a_2_54# invader_bullet_coord_y[3] gnd Gnd nfet w=10 l=2
+  ad=59.999996p pd=32u as=0 ps=0
M5027 OR2X1_6/Y OR2X1_6/a_2_54# vdd vdd pfet w=20 l=2
+  ad=100p pd=50u as=0 ps=0
M5028 OR2X1_6/Y OR2X1_6/a_2_54# gnd Gnd nfet w=10 l=2
+  ad=50p pd=30u as=0 ps=0
M5029 vdd invader_bullet_coord_y[2] OR2X1_6/a_9_54# vdd pfet w=40 l=2
+  ad=0 pd=0 as=0.12n ps=86u
M5030 OR2X1_6/a_9_54# invader_bullet_coord_y[3] OR2X1_6/a_2_54# vdd pfet w=40 l=2
+  ad=0 pd=0 as=0.2n ps=90u
M5031 gnd invader_bullet_coord_y[2] OR2X1_6/a_2_54# Gnd nfet w=10 l=2
+  ad=0 pd=0 as=0 ps=0
M5032 gnd INVX2_149/A OAI21X1_60/a_2_6# Gnd nfet w=20 l=2
+  ad=0 pd=0 as=0.22n ps=0.102m
M5033 vdd OAI21X1_60/C OAI21X1_60/Y vdd pfet w=20 l=2
+  ad=0 pd=0 as=0.22n ps=92u
M5034 OAI21X1_60/Y OAI21X1_60/C OAI21X1_60/a_2_6# Gnd nfet w=20 l=2
+  ad=100p pd=50u as=0 ps=0
M5035 OAI21X1_60/Y OAI22X1_7/B OAI21X1_60/a_9_54# vdd pfet w=40 l=2
+  ad=0 pd=0 as=0.12n ps=86u
M5036 OAI21X1_60/a_9_54# INVX2_149/A vdd vdd pfet w=40 l=2
+  ad=0 pd=0 as=0 ps=0
M5037 OAI21X1_60/a_2_6# OAI22X1_7/B gnd Gnd nfet w=20 l=2
+  ad=0 pd=0 as=0 ps=0
M5038 gnd INVX2_53/Y OAI21X1_71/a_2_6# Gnd nfet w=20 l=2
+  ad=0 pd=0 as=0.22n ps=0.102m
M5039 vdd OAI21X1_71/C OAI21X1_71/Y vdd pfet w=20 l=2
+  ad=0 pd=0 as=0.22n ps=92u
M5040 OAI21X1_71/Y OAI21X1_71/C OAI21X1_71/a_2_6# Gnd nfet w=20 l=2
+  ad=100p pd=50u as=0 ps=0
M5041 OAI21X1_71/Y OAI21X1_71/B OAI21X1_71/a_9_54# vdd pfet w=40 l=2
+  ad=0 pd=0 as=0.12n ps=86u
M5042 OAI21X1_71/a_9_54# INVX2_53/Y vdd vdd pfet w=40 l=2
+  ad=0 pd=0 as=0 ps=0
M5043 OAI21X1_71/a_2_6# OAI21X1_71/B gnd Gnd nfet w=20 l=2
+  ad=0 pd=0 as=0 ps=0
M5044 gnd OR2X1_13/Y OAI21X1_93/a_2_6# Gnd nfet w=20 l=2
+  ad=0 pd=0 as=0.22n ps=0.102m
M5045 vdd OAI21X1_93/C OAI21X1_93/Y vdd pfet w=20 l=2
+  ad=0 pd=0 as=0.22n ps=92u
M5046 OAI21X1_93/Y OAI21X1_93/C OAI21X1_93/a_2_6# Gnd nfet w=20 l=2
+  ad=100p pd=50u as=0 ps=0
M5047 OAI21X1_93/Y INVX2_132/A OAI21X1_93/a_9_54# vdd pfet w=40 l=2
+  ad=0 pd=0 as=0.12n ps=86u
M5048 OAI21X1_93/a_9_54# OR2X1_13/Y vdd vdd pfet w=40 l=2
+  ad=0 pd=0 as=0 ps=0
M5049 OAI21X1_93/a_2_6# INVX2_132/A gnd Gnd nfet w=20 l=2
+  ad=0 pd=0 as=0 ps=0
M5050 gnd INVX2_74/Y OAI21X1_82/a_2_6# Gnd nfet w=20 l=2
+  ad=0 pd=0 as=0.22n ps=0.102m
M5051 vdd INVX2_145/A OR2X1_9/B vdd pfet w=20 l=2
+  ad=0 pd=0 as=0.22n ps=92u
M5052 OR2X1_9/B INVX2_145/A OAI21X1_82/a_2_6# Gnd nfet w=20 l=2
+  ad=100p pd=50u as=0 ps=0
M5053 OR2X1_9/B INVX2_146/A OAI21X1_82/a_9_54# vdd pfet w=40 l=2
+  ad=0 pd=0 as=0.12n ps=86u
M5054 OAI21X1_82/a_9_54# INVX2_74/Y vdd vdd pfet w=40 l=2
+  ad=0 pd=0 as=0 ps=0
M5055 OAI21X1_82/a_2_6# INVX2_146/A gnd Gnd nfet w=20 l=2
+  ad=0 pd=0 as=0 ps=0
M5056 OR2X1_20/a_2_54# OR2X1_20/A gnd Gnd nfet w=10 l=2
+  ad=59.999996p pd=32u as=0 ps=0
M5057 OR2X1_20/Y OR2X1_20/a_2_54# vdd vdd pfet w=20 l=2
+  ad=100p pd=50u as=0 ps=0
M5058 OR2X1_20/Y OR2X1_20/a_2_54# gnd Gnd nfet w=10 l=2
+  ad=50p pd=30u as=0 ps=0
M5059 vdd OR2X1_20/B OR2X1_20/a_9_54# vdd pfet w=40 l=2
+  ad=0 pd=0 as=0.12n ps=86u
M5060 OR2X1_20/a_9_54# OR2X1_20/A OR2X1_20/a_2_54# vdd pfet w=40 l=2
+  ad=0 pd=0 as=0.2n ps=90u
M5061 gnd OR2X1_20/B OR2X1_20/a_2_54# Gnd nfet w=10 l=2
+  ad=0 pd=0 as=0 ps=0
M5062 OR2X1_13/A NAND3X1_41/A vdd vdd pfet w=20 l=2
+  ad=0.22n pd=0.102m as=0 ps=0
M5063 NAND3X1_41/a_9_6# NAND3X1_41/A gnd Gnd nfet w=30 l=2
+  ad=90p pd=66u as=0 ps=0
M5064 OR2X1_13/A INVX2_1/Y vdd vdd pfet w=20 l=2
+  ad=0 pd=0 as=0 ps=0
M5065 OR2X1_13/A INVX2_1/Y NAND3X1_41/a_14_6# Gnd nfet w=30 l=2
+  ad=0.15n pd=70u as=90p ps=66u
M5066 vdd OAI21X1_28/Y OR2X1_13/A vdd pfet w=20 l=2
+  ad=0 pd=0 as=0 ps=0
M5067 NAND3X1_41/a_14_6# OAI21X1_28/Y NAND3X1_41/a_9_6# Gnd nfet w=30 l=2
+  ad=0 pd=0 as=0 ps=0
M5068 INVX2_145/A INVX2_59/A vdd vdd pfet w=20 l=2
+  ad=0.22n pd=0.102m as=0 ps=0
M5069 NAND3X1_30/a_9_6# INVX2_59/A gnd Gnd nfet w=30 l=2
+  ad=90p pd=66u as=0 ps=0
M5070 INVX2_145/A XNOR2X1_2/Y vdd vdd pfet w=20 l=2
+  ad=0 pd=0 as=0 ps=0
M5071 INVX2_145/A XNOR2X1_2/Y NAND3X1_30/a_14_6# Gnd nfet w=30 l=2
+  ad=0.15n pd=70u as=90p ps=66u
M5072 vdd INVX2_146/A INVX2_145/A vdd pfet w=20 l=2
+  ad=0 pd=0 as=0 ps=0
M5073 NAND3X1_30/a_14_6# INVX2_146/A NAND3X1_30/a_9_6# Gnd nfet w=30 l=2
+  ad=0 pd=0 as=0 ps=0
M5074 NOR2X1_30/Y INVX2_29/Y gnd Gnd nfet w=10 l=2
+  ad=59.999996p pd=32u as=0 ps=0
M5075 NOR2X1_30/Y OR2X1_15/A NOR2X1_30/a_9_54# vdd pfet w=40 l=2
+  ad=0.2n pd=90u as=0.12n ps=86u
M5076 NOR2X1_30/a_9_54# INVX2_29/Y vdd vdd pfet w=40 l=2
+  ad=0 pd=0 as=0 ps=0
M5077 gnd OR2X1_15/A NOR2X1_30/Y Gnd nfet w=10 l=2
+  ad=0 pd=0 as=0 ps=0
M5078 NOR2X1_52/Y INVX2_98/Y gnd Gnd nfet w=10 l=2
+  ad=59.999996p pd=32u as=0 ps=0
M5079 NOR2X1_52/Y INVX2_95/A NOR2X1_52/a_9_54# vdd pfet w=40 l=2
+  ad=0.2n pd=90u as=0.12n ps=86u
M5080 NOR2X1_52/a_9_54# INVX2_98/Y vdd vdd pfet w=40 l=2
+  ad=0 pd=0 as=0 ps=0
M5081 gnd INVX2_95/A NOR2X1_52/Y Gnd nfet w=10 l=2
+  ad=0 pd=0 as=0 ps=0
M5082 NOR2X1_41/Y OR2X1_12/B gnd Gnd nfet w=10 l=2
+  ad=59.999996p pd=32u as=0 ps=0
M5083 NOR2X1_41/Y NOR2X1_41/B NOR2X1_41/a_9_54# vdd pfet w=40 l=2
+  ad=0.2n pd=90u as=0.12n ps=86u
M5084 NOR2X1_41/a_9_54# OR2X1_12/B vdd vdd pfet w=40 l=2
+  ad=0 pd=0 as=0 ps=0
M5085 gnd NOR2X1_41/B NOR2X1_41/Y Gnd nfet w=10 l=2
+  ad=0 pd=0 as=0 ps=0
M5086 NAND2X1_7/Y NOR2X1_23/Y vdd vdd pfet w=20 l=2
+  ad=0.12n pd=52u as=0 ps=0
M5087 NAND2X1_7/a_9_6# NOR2X1_23/Y gnd Gnd nfet w=20 l=2
+  ad=59.999996p pd=46u as=0 ps=0
M5088 vdd AND2X2_0/A NAND2X1_7/Y vdd pfet w=20 l=2
+  ad=0 pd=0 as=0 ps=0
M5089 NAND2X1_7/Y AND2X2_0/A NAND2X1_7/a_9_6# Gnd nfet w=20 l=2
+  ad=100p pd=50u as=0 ps=0
M5090 OR2X1_7/a_2_54# OR2X1_8/B gnd Gnd nfet w=10 l=2
+  ad=59.999996p pd=32u as=0 ps=0
M5091 OR2X1_7/Y OR2X1_7/a_2_54# vdd vdd pfet w=20 l=2
+  ad=100p pd=50u as=0 ps=0
M5092 OR2X1_7/Y OR2X1_7/a_2_54# gnd Gnd nfet w=10 l=2
+  ad=50p pd=30u as=0 ps=0
M5093 vdd OR2X1_7/B OR2X1_7/a_9_54# vdd pfet w=40 l=2
+  ad=0 pd=0 as=0.12n ps=86u
M5094 OR2X1_7/a_9_54# OR2X1_8/B OR2X1_7/a_2_54# vdd pfet w=40 l=2
+  ad=0 pd=0 as=0.2n ps=90u
M5095 gnd OR2X1_7/B OR2X1_7/a_2_54# Gnd nfet w=10 l=2
+  ad=0 pd=0 as=0 ps=0
M5096 gnd INVX2_185/A OAI21X1_50/a_2_6# Gnd nfet w=20 l=2
+  ad=0 pd=0 as=0.22n ps=0.102m
M5097 vdd OAI21X1_51/Y OAI21X1_50/Y vdd pfet w=20 l=2
+  ad=0 pd=0 as=0.22n ps=92u
M5098 OAI21X1_50/Y OAI21X1_51/Y OAI21X1_50/a_2_6# Gnd nfet w=20 l=2
+  ad=100p pd=50u as=0 ps=0
M5099 OAI21X1_50/Y INVX2_18/Y OAI21X1_50/a_9_54# vdd pfet w=40 l=2
+  ad=0 pd=0 as=0.12n ps=86u
M5100 OAI21X1_50/a_9_54# INVX2_185/A vdd vdd pfet w=40 l=2
+  ad=0 pd=0 as=0 ps=0
M5101 OAI21X1_50/a_2_6# INVX2_18/Y gnd Gnd nfet w=20 l=2
+  ad=0 pd=0 as=0 ps=0
M5102 gnd OAI21X1_61/A OAI21X1_61/a_2_6# Gnd nfet w=20 l=2
+  ad=0 pd=0 as=0.22n ps=0.102m
M5103 vdd invader_2_coord_y[3] OAI21X1_61/Y vdd pfet w=20 l=2
+  ad=0 pd=0 as=0.22n ps=92u
M5104 OAI21X1_61/Y invader_2_coord_y[3] OAI21X1_61/a_2_6# Gnd nfet w=20 l=2
+  ad=100p pd=50u as=0 ps=0
M5105 OAI21X1_61/Y INVX2_148/Y OAI21X1_61/a_9_54# vdd pfet w=40 l=2
+  ad=0 pd=0 as=0.12n ps=86u
M5106 OAI21X1_61/a_9_54# OAI21X1_61/A vdd vdd pfet w=40 l=2
+  ad=0 pd=0 as=0 ps=0
M5107 OAI21X1_61/a_2_6# INVX2_148/Y gnd Gnd nfet w=20 l=2
+  ad=0 pd=0 as=0 ps=0
M5108 gnd AND2X2_14/B OAI21X1_72/a_2_6# Gnd nfet w=20 l=2
+  ad=0 pd=0 as=0.22n ps=0.102m
M5109 vdd OAI21X1_72/C OAI21X1_72/Y vdd pfet w=20 l=2
+  ad=0 pd=0 as=0.22n ps=92u
M5110 OAI21X1_72/Y OAI21X1_72/C OAI21X1_72/a_2_6# Gnd nfet w=20 l=2
+  ad=100p pd=50u as=0 ps=0
M5111 OAI21X1_72/Y INVX2_84/Y OAI21X1_72/a_9_54# vdd pfet w=40 l=2
+  ad=0 pd=0 as=0.12n ps=86u
M5112 OAI21X1_72/a_9_54# AND2X2_14/B vdd vdd pfet w=40 l=2
+  ad=0 pd=0 as=0 ps=0
M5113 OAI21X1_72/a_2_6# INVX2_84/Y gnd Gnd nfet w=20 l=2
+  ad=0 pd=0 as=0 ps=0
M5114 gnd OAI21X1_97/A OAI21X1_94/a_2_6# Gnd nfet w=20 l=2
+  ad=0 pd=0 as=0.22n ps=0.102m
M5115 vdd INVX2_133/Y OAI21X1_94/Y vdd pfet w=20 l=2
+  ad=0 pd=0 as=0.22n ps=92u
M5116 OAI21X1_94/Y INVX2_133/Y OAI21X1_94/a_2_6# Gnd nfet w=20 l=2
+  ad=100p pd=50u as=0 ps=0
M5117 OAI21X1_94/Y INVX2_93/Y OAI21X1_94/a_9_54# vdd pfet w=40 l=2
+  ad=0 pd=0 as=0.12n ps=86u
M5118 OAI21X1_94/a_9_54# OAI21X1_97/A vdd vdd pfet w=40 l=2
+  ad=0 pd=0 as=0 ps=0
M5119 OAI21X1_94/a_2_6# INVX2_93/Y gnd Gnd nfet w=20 l=2
+  ad=0 pd=0 as=0 ps=0
M5120 gnd INVX2_71/Y OAI21X1_83/a_2_6# Gnd nfet w=20 l=2
+  ad=0 pd=0 as=0.22n ps=0.102m
M5121 vdd OAI21X1_83/C OAI21X1_83/Y vdd pfet w=20 l=2
+  ad=0 pd=0 as=0.22n ps=92u
M5122 OAI21X1_83/Y OAI21X1_83/C OAI21X1_83/a_2_6# Gnd nfet w=20 l=2
+  ad=100p pd=50u as=0 ps=0
M5123 OAI21X1_83/Y INVX2_146/A OAI21X1_83/a_9_54# vdd pfet w=40 l=2
+  ad=0 pd=0 as=0.12n ps=86u
M5124 OAI21X1_83/a_9_54# INVX2_71/Y vdd vdd pfet w=40 l=2
+  ad=0 pd=0 as=0 ps=0
M5125 OAI21X1_83/a_2_6# INVX2_146/A gnd Gnd nfet w=20 l=2
+  ad=0 pd=0 as=0 ps=0
M5126 OR2X1_10/a_2_54# invader_1_coord_y[0] gnd Gnd nfet w=10 l=2
+  ad=59.999996p pd=32u as=0 ps=0
M5127 OR2X1_10/Y OR2X1_10/a_2_54# vdd vdd pfet w=20 l=2
+  ad=100p pd=50u as=0 ps=0
M5128 OR2X1_10/Y OR2X1_10/a_2_54# gnd Gnd nfet w=10 l=2
+  ad=50p pd=30u as=0 ps=0
M5129 vdd OR2X1_9/A OR2X1_10/a_9_54# vdd pfet w=40 l=2
+  ad=0 pd=0 as=0.12n ps=86u
M5130 OR2X1_10/a_9_54# invader_1_coord_y[0] OR2X1_10/a_2_54# vdd pfet w=40 l=2
+  ad=0 pd=0 as=0.2n ps=90u
M5131 gnd OR2X1_9/A OR2X1_10/a_2_54# Gnd nfet w=10 l=2
+  ad=0 pd=0 as=0 ps=0
M5132 AND2X2_20/a_2_6# LATCH_0/Q vdd vdd pfet w=20 l=2
+  ad=0.12n pd=52u as=0 ps=0
M5133 AND2X2_20/a_9_6# LATCH_0/Q AND2X2_20/a_2_6# Gnd nfet w=20 l=2
+  ad=59.999996p pd=46u as=100p ps=50u
M5134 AND2X2_20/Y AND2X2_20/a_2_6# gnd Gnd nfet w=20 l=2
+  ad=100p pd=50u as=0 ps=0
M5135 AND2X2_20/Y AND2X2_20/a_2_6# vdd vdd pfet w=40 l=2
+  ad=0.2n pd=90u as=0 ps=0
M5136 vdd INVX2_165/Y AND2X2_20/a_2_6# vdd pfet w=20 l=2
+  ad=0 pd=0 as=0 ps=0
M5137 gnd INVX2_165/Y AND2X2_20/a_9_6# Gnd nfet w=20 l=2
+  ad=0 pd=0 as=0 ps=0
M5138 INVX2_147/A INVX2_29/A vdd vdd pfet w=20 l=2
+  ad=0.22n pd=0.102m as=0 ps=0
M5139 NAND3X1_20/a_9_6# INVX2_29/A gnd Gnd nfet w=30 l=2
+  ad=90p pd=66u as=0 ps=0
M5140 INVX2_147/A XNOR2X1_1/Y vdd vdd pfet w=20 l=2
+  ad=0 pd=0 as=0 ps=0
M5141 INVX2_147/A XNOR2X1_1/Y NAND3X1_20/a_14_6# Gnd nfet w=30 l=2
+  ad=0.15n pd=70u as=90p ps=66u
M5142 vdd INVX2_148/A INVX2_147/A vdd pfet w=20 l=2
+  ad=0 pd=0 as=0 ps=0
M5143 NAND3X1_20/a_14_6# INVX2_148/A NAND3X1_20/a_9_6# Gnd nfet w=30 l=2
+  ad=0 pd=0 as=0 ps=0
M5144 OAI21X1_83/C INVX2_146/A vdd vdd pfet w=20 l=2
+  ad=0.22n pd=0.102m as=0 ps=0
M5145 NAND3X1_31/a_9_6# INVX2_146/A gnd Gnd nfet w=30 l=2
+  ad=90p pd=66u as=0 ps=0
M5146 OAI21X1_83/C NOR2X1_34/Y vdd vdd pfet w=20 l=2
+  ad=0 pd=0 as=0 ps=0
M5147 OAI21X1_83/C NOR2X1_34/Y NAND3X1_31/a_14_6# Gnd nfet w=30 l=2
+  ad=0.15n pd=70u as=90p ps=66u
M5148 vdd INVX2_71/Y OAI21X1_83/C vdd pfet w=20 l=2
+  ad=0 pd=0 as=0 ps=0
M5149 NAND3X1_31/a_14_6# INVX2_71/Y NAND3X1_31/a_9_6# Gnd nfet w=30 l=2
+  ad=0 pd=0 as=0 ps=0
M5150 NAND3X1_42/Y player_coord_x[1] vdd vdd pfet w=20 l=2
+  ad=0.22n pd=0.102m as=0 ps=0
M5151 NAND3X1_42/a_9_6# player_coord_x[1] gnd Gnd nfet w=30 l=2
+  ad=90p pd=66u as=0 ps=0
M5152 NAND3X1_42/Y INVX2_161/Y vdd vdd pfet w=20 l=2
+  ad=0 pd=0 as=0 ps=0
M5153 NAND3X1_42/Y INVX2_161/Y NAND3X1_42/a_14_6# Gnd nfet w=30 l=2
+  ad=0.15n pd=70u as=90p ps=66u
M5154 vdd player_coord_x[0] NAND3X1_42/Y vdd pfet w=20 l=2
+  ad=0 pd=0 as=0 ps=0
M5155 NAND3X1_42/a_14_6# player_coord_x[0] NAND3X1_42/a_9_6# Gnd nfet w=30 l=2
+  ad=0 pd=0 as=0 ps=0
M5156 NOR2X1_20/Y NOR2X1_20/A gnd Gnd nfet w=10 l=2
+  ad=59.999996p pd=32u as=0 ps=0
M5157 NOR2X1_20/Y NOR2X1_20/B NOR2X1_20/a_9_54# vdd pfet w=40 l=2
+  ad=0.2n pd=90u as=0.12n ps=86u
M5158 NOR2X1_20/a_9_54# NOR2X1_20/A vdd vdd pfet w=40 l=2
+  ad=0 pd=0 as=0 ps=0
M5159 gnd NOR2X1_20/B NOR2X1_20/Y Gnd nfet w=10 l=2
+  ad=0 pd=0 as=0 ps=0
M5160 INVX2_97/A INVX2_95/Y gnd Gnd nfet w=10 l=2
+  ad=59.999996p pd=32u as=0 ps=0
M5161 INVX2_97/A INVX2_98/A NOR2X1_53/a_9_54# vdd pfet w=40 l=2
+  ad=0.2n pd=90u as=0.12n ps=86u
M5162 NOR2X1_53/a_9_54# INVX2_95/Y vdd vdd pfet w=40 l=2
+  ad=0 pd=0 as=0 ps=0
M5163 gnd INVX2_98/A INVX2_97/A Gnd nfet w=10 l=2
+  ad=0 pd=0 as=0 ps=0
M5164 NOR2X1_42/Y NOR2X1_42/A gnd Gnd nfet w=10 l=2
+  ad=59.999996p pd=32u as=0 ps=0
M5165 NOR2X1_42/Y OR2X1_12/Y NOR2X1_42/a_9_54# vdd pfet w=40 l=2
+  ad=0.2n pd=90u as=0.12n ps=86u
M5166 NOR2X1_42/a_9_54# NOR2X1_42/A vdd vdd pfet w=40 l=2
+  ad=0 pd=0 as=0 ps=0
M5167 gnd OR2X1_12/Y NOR2X1_42/Y Gnd nfet w=10 l=2
+  ad=0 pd=0 as=0 ps=0
M5168 NOR2X1_31/Y NOR2X1_31/A gnd Gnd nfet w=10 l=2
+  ad=59.999996p pd=32u as=0 ps=0
M5169 NOR2X1_31/Y INVX2_30/Y NOR2X1_31/a_9_54# vdd pfet w=40 l=2
+  ad=0.2n pd=90u as=0.12n ps=86u
M5170 NOR2X1_31/a_9_54# NOR2X1_31/A vdd vdd pfet w=40 l=2
+  ad=0 pd=0 as=0 ps=0
M5171 gnd INVX2_30/Y NOR2X1_31/Y Gnd nfet w=10 l=2
+  ad=0 pd=0 as=0 ps=0
M5172 NAND2X1_8/Y INVX2_0/Y vdd vdd pfet w=20 l=2
+  ad=0.12n pd=52u as=0 ps=0
M5173 NAND2X1_8/a_9_6# INVX2_0/Y gnd Gnd nfet w=20 l=2
+  ad=59.999996p pd=46u as=0 ps=0
M5174 vdd INVX2_11/Y NAND2X1_8/Y vdd pfet w=20 l=2
+  ad=0 pd=0 as=0 ps=0
M5175 NAND2X1_8/Y INVX2_11/Y NAND2X1_8/a_9_6# Gnd nfet w=20 l=2
+  ad=100p pd=50u as=0 ps=0
M5176 OR2X1_8/a_2_54# invader_2_coord_y[0] gnd Gnd nfet w=10 l=2
+  ad=59.999996p pd=32u as=0 ps=0
M5177 OR2X1_8/Y OR2X1_8/a_2_54# vdd vdd pfet w=20 l=2
+  ad=100p pd=50u as=0 ps=0
M5178 OR2X1_8/Y OR2X1_8/a_2_54# gnd Gnd nfet w=10 l=2
+  ad=50p pd=30u as=0 ps=0
M5179 vdd OR2X1_8/B OR2X1_8/a_9_54# vdd pfet w=40 l=2
+  ad=0 pd=0 as=0.12n ps=86u
M5180 OR2X1_8/a_9_54# invader_2_coord_y[0] OR2X1_8/a_2_54# vdd pfet w=40 l=2
+  ad=0 pd=0 as=0.2n ps=90u
M5181 gnd OR2X1_8/B OR2X1_8/a_2_54# Gnd nfet w=10 l=2
+  ad=0 pd=0 as=0 ps=0
M5182 gnd player_coord_x[3] OAI21X1_51/a_2_6# Gnd nfet w=20 l=2
+  ad=0 pd=0 as=0.22n ps=0.102m
M5183 vdd INVX2_185/A OAI21X1_51/Y vdd pfet w=20 l=2
+  ad=0 pd=0 as=0.22n ps=92u
M5184 OAI21X1_51/Y INVX2_185/A OAI21X1_51/a_2_6# Gnd nfet w=20 l=2
+  ad=100p pd=50u as=0 ps=0
M5185 OAI21X1_51/Y OR2X1_15/A OAI21X1_51/a_9_54# vdd pfet w=40 l=2
+  ad=0 pd=0 as=0.12n ps=86u
M5186 OAI21X1_51/a_9_54# player_coord_x[3] vdd vdd pfet w=40 l=2
+  ad=0 pd=0 as=0 ps=0
M5187 OAI21X1_51/a_2_6# OR2X1_15/A gnd Gnd nfet w=20 l=2
+  ad=0 pd=0 as=0 ps=0
M5188 gnd NAND2X1_1/Y OAI21X1_40/a_2_6# Gnd nfet w=20 l=2
+  ad=0 pd=0 as=0.22n ps=0.102m
M5189 vdd OAI21X1_40/C OAI21X1_40/Y vdd pfet w=20 l=2
+  ad=0 pd=0 as=0.22n ps=92u
M5190 OAI21X1_40/Y OAI21X1_40/C OAI21X1_40/a_2_6# Gnd nfet w=20 l=2
+  ad=100p pd=50u as=0 ps=0
M5191 OAI21X1_40/Y INVX2_3/Y OAI21X1_40/a_9_54# vdd pfet w=40 l=2
+  ad=0 pd=0 as=0.12n ps=86u
M5192 OAI21X1_40/a_9_54# NAND2X1_1/Y vdd vdd pfet w=40 l=2
+  ad=0 pd=0 as=0 ps=0
M5193 OAI21X1_40/a_2_6# INVX2_3/Y gnd Gnd nfet w=20 l=2
+  ad=0 pd=0 as=0 ps=0
M5194 gnd INVX2_36/Y OAI21X1_62/a_2_6# Gnd nfet w=20 l=2
+  ad=0 pd=0 as=0.22n ps=0.102m
M5195 vdd INVX2_147/A OR2X1_7/B vdd pfet w=20 l=2
+  ad=0 pd=0 as=0.22n ps=92u
M5196 OR2X1_7/B INVX2_147/A OAI21X1_62/a_2_6# Gnd nfet w=20 l=2
+  ad=100p pd=50u as=0 ps=0
M5197 OR2X1_7/B INVX2_148/A OAI21X1_62/a_9_54# vdd pfet w=40 l=2
+  ad=0 pd=0 as=0.12n ps=86u
M5198 OAI21X1_62/a_9_54# INVX2_36/Y vdd vdd pfet w=40 l=2
+  ad=0 pd=0 as=0 ps=0
M5199 OAI21X1_62/a_2_6# INVX2_148/A gnd Gnd nfet w=20 l=2
+  ad=0 pd=0 as=0 ps=0
M5200 gnd invader_1_coord_x[1] OAI21X1_73/a_2_6# Gnd nfet w=20 l=2
+  ad=0 pd=0 as=0.22n ps=0.102m
M5201 vdd invader_1_coord_x[2] AND2X2_11/A vdd pfet w=20 l=2
+  ad=0 pd=0 as=0.22n ps=92u
M5202 AND2X2_11/A invader_1_coord_x[2] OAI21X1_73/a_2_6# Gnd nfet w=20 l=2
+  ad=100p pd=50u as=0 ps=0
M5203 AND2X2_11/A invader_1_coord_x[0] OAI21X1_73/a_9_54# vdd pfet w=40 l=2
+  ad=0 pd=0 as=0.12n ps=86u
M5204 OAI21X1_73/a_9_54# invader_1_coord_x[1] vdd vdd pfet w=40 l=2
+  ad=0 pd=0 as=0 ps=0
M5205 OAI21X1_73/a_2_6# invader_1_coord_x[0] gnd Gnd nfet w=20 l=2
+  ad=0 pd=0 as=0 ps=0
M5206 gnd OAI21X1_97/A OAI21X1_95/a_2_6# Gnd nfet w=20 l=2
+  ad=0 pd=0 as=0.22n ps=0.102m
M5207 vdd INVX2_133/Y OAI21X1_95/Y vdd pfet w=20 l=2
+  ad=0 pd=0 as=0.22n ps=92u
M5208 OAI21X1_95/Y INVX2_133/Y OAI21X1_95/a_2_6# Gnd nfet w=20 l=2
+  ad=100p pd=50u as=0 ps=0
M5209 OAI21X1_95/Y INVX2_92/Y OAI21X1_95/a_9_54# vdd pfet w=40 l=2
+  ad=0 pd=0 as=0.12n ps=86u
M5210 OAI21X1_95/a_9_54# OAI21X1_97/A vdd vdd pfet w=40 l=2
+  ad=0 pd=0 as=0 ps=0
M5211 OAI21X1_95/a_2_6# INVX2_92/Y gnd Gnd nfet w=20 l=2
+  ad=0 pd=0 as=0 ps=0
M5212 gnd INVX2_59/Y OAI21X1_84/a_2_6# Gnd nfet w=20 l=2
+  ad=0 pd=0 as=0.22n ps=0.102m
M5213 vdd INVX2_136/Y INVX2_146/A vdd pfet w=20 l=2
+  ad=0 pd=0 as=0.22n ps=92u
M5214 INVX2_146/A INVX2_136/Y OAI21X1_84/a_2_6# Gnd nfet w=20 l=2
+  ad=100p pd=50u as=0 ps=0
M5215 INVX2_146/A INVX2_144/Y OAI21X1_84/a_9_54# vdd pfet w=40 l=2
+  ad=0 pd=0 as=0.12n ps=86u
M5216 OAI21X1_84/a_9_54# INVX2_59/Y vdd vdd pfet w=40 l=2
+  ad=0 pd=0 as=0 ps=0
M5217 OAI21X1_84/a_2_6# INVX2_144/Y gnd Gnd nfet w=20 l=2
+  ad=0 pd=0 as=0 ps=0
M5218 OR2X1_11/a_2_54# OR2X1_11/A gnd Gnd nfet w=10 l=2
+  ad=59.999996p pd=32u as=0 ps=0
M5219 OR2X1_11/Y OR2X1_11/a_2_54# vdd vdd pfet w=20 l=2
+  ad=100p pd=50u as=0 ps=0
M5220 OR2X1_11/Y OR2X1_11/a_2_54# gnd Gnd nfet w=10 l=2
+  ad=50p pd=30u as=0 ps=0
M5221 vdd OR2X1_11/B OR2X1_11/a_9_54# vdd pfet w=40 l=2
+  ad=0 pd=0 as=0.12n ps=86u
M5222 OR2X1_11/a_9_54# OR2X1_11/A OR2X1_11/a_2_54# vdd pfet w=40 l=2
+  ad=0 pd=0 as=0.2n ps=90u
M5223 gnd OR2X1_11/B OR2X1_11/a_2_54# Gnd nfet w=10 l=2
+  ad=0 pd=0 as=0 ps=0
M5224 AND2X2_21/a_2_6# LATCH_1/Q vdd vdd pfet w=20 l=2
+  ad=0.12n pd=52u as=0 ps=0
M5225 AND2X2_21/a_9_6# LATCH_1/Q AND2X2_21/a_2_6# Gnd nfet w=20 l=2
+  ad=59.999996p pd=46u as=100p ps=50u
M5226 AND2X2_21/Y AND2X2_21/a_2_6# gnd Gnd nfet w=20 l=2
+  ad=100p pd=50u as=0 ps=0
M5227 AND2X2_21/Y AND2X2_21/a_2_6# vdd vdd pfet w=40 l=2
+  ad=0.2n pd=90u as=0 ps=0
M5228 vdd INVX2_165/Y AND2X2_21/a_2_6# vdd pfet w=20 l=2
+  ad=0 pd=0 as=0 ps=0
M5229 gnd INVX2_165/Y AND2X2_21/a_9_6# Gnd nfet w=20 l=2
+  ad=0 pd=0 as=0 ps=0
M5230 AND2X2_10/a_2_6# AOI21X1_4/Y vdd vdd pfet w=20 l=2
+  ad=0.12n pd=52u as=0 ps=0
M5231 AND2X2_10/a_9_6# AOI21X1_4/Y AND2X2_10/a_2_6# Gnd nfet w=20 l=2
+  ad=59.999996p pd=46u as=100p ps=50u
M5232 AND2X2_10/Y AND2X2_10/a_2_6# gnd Gnd nfet w=20 l=2
+  ad=100p pd=50u as=0 ps=0
M5233 AND2X2_10/Y AND2X2_10/a_2_6# vdd vdd pfet w=40 l=2
+  ad=0.2n pd=90u as=0 ps=0
M5234 vdd OR2X1_0/Y AND2X2_10/a_2_6# vdd pfet w=20 l=2
+  ad=0 pd=0 as=0 ps=0
M5235 gnd OR2X1_0/Y AND2X2_10/a_9_6# Gnd nfet w=20 l=2
+  ad=0 pd=0 as=0 ps=0
M5236 OAI21X1_35/C OAI21X1_34/C vdd vdd pfet w=20 l=2
+  ad=0.22n pd=0.102m as=0 ps=0
M5237 NAND3X1_10/a_9_6# OAI21X1_34/C gnd Gnd nfet w=30 l=2
+  ad=90p pd=66u as=0 ps=0
M5238 OAI21X1_35/C HAX1_4/YS vdd vdd pfet w=20 l=2
+  ad=0 pd=0 as=0 ps=0
M5239 OAI21X1_35/C HAX1_4/YS NAND3X1_10/a_14_6# Gnd nfet w=30 l=2
+  ad=0.15n pd=70u as=90p ps=66u
M5240 vdd INVX2_4/Y OAI21X1_35/C vdd pfet w=20 l=2
+  ad=0 pd=0 as=0 ps=0
M5241 NAND3X1_10/a_14_6# INVX2_4/Y NAND3X1_10/a_9_6# Gnd nfet w=30 l=2
+  ad=0 pd=0 as=0 ps=0
M5242 OAI21X1_63/C INVX2_148/A vdd vdd pfet w=20 l=2
+  ad=0.22n pd=0.102m as=0 ps=0
M5243 NAND3X1_21/a_9_6# INVX2_148/A gnd Gnd nfet w=30 l=2
+  ad=90p pd=66u as=0 ps=0
M5244 OAI21X1_63/C NOR2X1_30/Y vdd vdd pfet w=20 l=2
+  ad=0 pd=0 as=0 ps=0
M5245 OAI21X1_63/C NOR2X1_30/Y NAND3X1_21/a_14_6# Gnd nfet w=30 l=2
+  ad=0.15n pd=70u as=90p ps=66u
M5246 vdd INVX2_31/Y OAI21X1_63/C vdd pfet w=20 l=2
+  ad=0 pd=0 as=0 ps=0
M5247 NAND3X1_21/a_14_6# INVX2_31/Y NAND3X1_21/a_9_6# Gnd nfet w=30 l=2
+  ad=0 pd=0 as=0 ps=0
M5248 OAI21X1_90/C NAND2X1_1/B vdd vdd pfet w=20 l=2
+  ad=0.22n pd=0.102m as=0 ps=0
M5249 NAND3X1_32/a_9_6# NAND2X1_1/B gnd Gnd nfet w=30 l=2
+  ad=90p pd=66u as=0 ps=0
M5250 OAI21X1_90/C INVX2_58/A vdd vdd pfet w=20 l=2
+  ad=0 pd=0 as=0 ps=0
M5251 OAI21X1_90/C INVX2_58/A NAND3X1_32/a_14_6# Gnd nfet w=30 l=2
+  ad=0.15n pd=70u as=90p ps=66u
M5252 vdd INVX2_57/Y OAI21X1_90/C vdd pfet w=20 l=2
+  ad=0 pd=0 as=0 ps=0
M5253 NAND3X1_32/a_14_6# INVX2_57/Y NAND3X1_32/a_9_6# Gnd nfet w=30 l=2
+  ad=0 pd=0 as=0 ps=0
M5254 INVX2_163/A INVX2_176/Y vdd vdd pfet w=20 l=2
+  ad=0.22n pd=0.102m as=0 ps=0
M5255 NAND3X1_43/a_9_6# INVX2_176/Y gnd Gnd nfet w=30 l=2
+  ad=90p pd=66u as=0 ps=0
M5256 INVX2_163/A INVX2_161/Y vdd vdd pfet w=20 l=2
+  ad=0 pd=0 as=0 ps=0
M5257 INVX2_163/A INVX2_161/Y NAND3X1_43/a_14_6# Gnd nfet w=30 l=2
+  ad=0.15n pd=70u as=90p ps=66u
M5258 vdd OR2X1_17/A INVX2_163/A vdd pfet w=20 l=2
+  ad=0 pd=0 as=0 ps=0
M5259 NAND3X1_43/a_14_6# OR2X1_17/A NAND3X1_43/a_9_6# Gnd nfet w=30 l=2
+  ad=0 pd=0 as=0 ps=0
M5260 NOR2X1_21/Y NOR2X1_22/Y gnd Gnd nfet w=10 l=2
+  ad=59.999996p pd=32u as=0 ps=0
M5261 NOR2X1_21/Y INVX2_10/Y NOR2X1_21/a_9_54# vdd pfet w=40 l=2
+  ad=0.2n pd=90u as=0.12n ps=86u
M5262 NOR2X1_21/a_9_54# NOR2X1_22/Y vdd vdd pfet w=40 l=2
+  ad=0 pd=0 as=0 ps=0
M5263 gnd INVX2_10/Y NOR2X1_21/Y Gnd nfet w=10 l=2
+  ad=0 pd=0 as=0 ps=0
M5264 NOR2X1_10/Y invader_1_coord_x[1] gnd Gnd nfet w=10 l=2
+  ad=59.999996p pd=32u as=0 ps=0
M5265 NOR2X1_10/Y invader_1_coord_x[0] NOR2X1_10/a_9_54# vdd pfet w=40 l=2
+  ad=0.2n pd=90u as=0.12n ps=86u
M5266 NOR2X1_10/a_9_54# invader_1_coord_x[1] vdd vdd pfet w=40 l=2
+  ad=0 pd=0 as=0 ps=0
M5267 gnd invader_1_coord_x[0] NOR2X1_10/Y Gnd nfet w=10 l=2
+  ad=0 pd=0 as=0 ps=0
M5268 NOR2X1_43/Y OR2X1_13/Y gnd Gnd nfet w=10 l=2
+  ad=59.999996p pd=32u as=0 ps=0
M5269 NOR2X1_43/Y shield_hp[1] NOR2X1_43/a_9_54# vdd pfet w=40 l=2
+  ad=0.2n pd=90u as=0.12n ps=86u
M5270 NOR2X1_43/a_9_54# OR2X1_13/Y vdd vdd pfet w=40 l=2
+  ad=0 pd=0 as=0 ps=0
M5271 gnd shield_hp[1] NOR2X1_43/Y Gnd nfet w=10 l=2
+  ad=0 pd=0 as=0 ps=0
M5272 NOR2X1_54/Y NOR2X1_54/A gnd Gnd nfet w=10 l=2
+  ad=59.999996p pd=32u as=0 ps=0
M5273 NOR2X1_54/Y OR2X1_18/A NOR2X1_54/a_9_54# vdd pfet w=40 l=2
+  ad=0.2n pd=90u as=0.12n ps=86u
M5274 NOR2X1_54/a_9_54# NOR2X1_54/A vdd vdd pfet w=40 l=2
+  ad=0 pd=0 as=0 ps=0
M5275 gnd OR2X1_18/A NOR2X1_54/Y Gnd nfet w=10 l=2
+  ad=0 pd=0 as=0 ps=0
M5276 INVX2_29/A INVX2_26/Y gnd Gnd nfet w=10 l=2
+  ad=59.999996p pd=32u as=0 ps=0
M5277 INVX2_29/A NOR2X1_32/B NOR2X1_32/a_9_54# vdd pfet w=40 l=2
+  ad=0.2n pd=90u as=0.12n ps=86u
M5278 NOR2X1_32/a_9_54# INVX2_26/Y vdd vdd pfet w=40 l=2
+  ad=0 pd=0 as=0 ps=0
M5279 gnd NOR2X1_32/B INVX2_29/A Gnd nfet w=10 l=2
+  ad=0 pd=0 as=0 ps=0
M5280 NAND2X1_9/Y INVX2_12/Y vdd vdd pfet w=20 l=2
+  ad=0.12n pd=52u as=0 ps=0
M5281 NAND2X1_9/a_9_6# INVX2_12/Y gnd Gnd nfet w=20 l=2
+  ad=59.999996p pd=46u as=0 ps=0
M5282 vdd NOR2X1_17/Y NAND2X1_9/Y vdd pfet w=20 l=2
+  ad=0 pd=0 as=0 ps=0
M5283 NAND2X1_9/Y NOR2X1_17/Y NAND2X1_9/a_9_6# Gnd nfet w=20 l=2
+  ad=100p pd=50u as=0 ps=0
M5284 OR2X1_9/a_2_54# OR2X1_9/A gnd Gnd nfet w=10 l=2
+  ad=59.999996p pd=32u as=0 ps=0
M5285 OR2X1_9/Y OR2X1_9/a_2_54# vdd vdd pfet w=20 l=2
+  ad=100p pd=50u as=0 ps=0
M5286 OR2X1_9/Y OR2X1_9/a_2_54# gnd Gnd nfet w=10 l=2
+  ad=50p pd=30u as=0 ps=0
M5287 vdd OR2X1_9/B OR2X1_9/a_9_54# vdd pfet w=40 l=2
+  ad=0 pd=0 as=0.12n ps=86u
M5288 OR2X1_9/a_9_54# OR2X1_9/A OR2X1_9/a_2_54# vdd pfet w=40 l=2
+  ad=0 pd=0 as=0.2n ps=90u
M5289 gnd OR2X1_9/B OR2X1_9/a_2_54# Gnd nfet w=10 l=2
+  ad=0 pd=0 as=0 ps=0
M5290 gnd shield_coord_x[1] OAI21X1_30/a_2_6# Gnd nfet w=20 l=2
+  ad=0 pd=0 as=0.22n ps=0.102m
M5291 vdd INVX2_7/Y AOI22X1_9/D vdd pfet w=20 l=2
+  ad=0 pd=0 as=0.22n ps=92u
M5292 AOI22X1_9/D INVX2_7/Y OAI21X1_30/a_2_6# Gnd nfet w=20 l=2
+  ad=100p pd=50u as=0 ps=0
M5293 AOI22X1_9/D invader_bullet_coord_x[1] OAI21X1_30/a_9_54# vdd pfet w=40 l=2
+  ad=0 pd=0 as=0.12n ps=86u
M5294 OAI21X1_30/a_9_54# shield_coord_x[1] vdd vdd pfet w=40 l=2
+  ad=0 pd=0 as=0 ps=0
M5295 OAI21X1_30/a_2_6# invader_bullet_coord_x[1] gnd Gnd nfet w=20 l=2
+  ad=0 pd=0 as=0 ps=0
M5296 gnd INVX2_23/Y OAI21X1_52/a_2_6# Gnd nfet w=20 l=2
+  ad=0 pd=0 as=0.22n ps=0.102m
M5297 vdd INVX2_17/A INVX2_24/A vdd pfet w=20 l=2
+  ad=0 pd=0 as=0.22n ps=92u
M5298 INVX2_24/A INVX2_17/A OAI21X1_52/a_2_6# Gnd nfet w=20 l=2
+  ad=100p pd=50u as=0 ps=0
M5299 INVX2_24/A NOR2X1_23/B OAI21X1_52/a_9_54# vdd pfet w=40 l=2
+  ad=0 pd=0 as=0.12n ps=86u
M5300 OAI21X1_52/a_9_54# INVX2_23/Y vdd vdd pfet w=40 l=2
+  ad=0 pd=0 as=0 ps=0
M5301 OAI21X1_52/a_2_6# NOR2X1_23/B gnd Gnd nfet w=20 l=2
+  ad=0 pd=0 as=0 ps=0
M5302 gnd NAND2X1_1/Y OAI21X1_41/a_2_6# Gnd nfet w=20 l=2
+  ad=0 pd=0 as=0.22n ps=0.102m
M5303 vdd OAI21X1_41/C OAI21X1_41/Y vdd pfet w=20 l=2
+  ad=0 pd=0 as=0.22n ps=92u
M5304 OAI21X1_41/Y OAI21X1_41/C OAI21X1_41/a_2_6# Gnd nfet w=20 l=2
+  ad=100p pd=50u as=0 ps=0
M5305 OAI21X1_41/Y INVX2_4/Y OAI21X1_41/a_9_54# vdd pfet w=40 l=2
+  ad=0 pd=0 as=0.12n ps=86u
M5306 OAI21X1_41/a_9_54# NAND2X1_1/Y vdd vdd pfet w=40 l=2
+  ad=0 pd=0 as=0 ps=0
M5307 OAI21X1_41/a_2_6# INVX2_4/Y gnd Gnd nfet w=20 l=2
+  ad=0 pd=0 as=0 ps=0
M5308 gnd INVX2_31/Y OAI21X1_63/a_2_6# Gnd nfet w=20 l=2
+  ad=0 pd=0 as=0.22n ps=0.102m
M5309 vdd OAI21X1_63/C OAI21X1_63/Y vdd pfet w=20 l=2
+  ad=0 pd=0 as=0.22n ps=92u
M5310 OAI21X1_63/Y OAI21X1_63/C OAI21X1_63/a_2_6# Gnd nfet w=20 l=2
+  ad=100p pd=50u as=0 ps=0
M5311 OAI21X1_63/Y INVX2_148/A OAI21X1_63/a_9_54# vdd pfet w=40 l=2
+  ad=0 pd=0 as=0.12n ps=86u
M5312 OAI21X1_63/a_9_54# INVX2_31/Y vdd vdd pfet w=40 l=2
+  ad=0 pd=0 as=0 ps=0
M5313 OAI21X1_63/a_2_6# INVX2_148/A gnd Gnd nfet w=20 l=2
+  ad=0 pd=0 as=0 ps=0
M5314 gnd OAI21X1_97/A OAI21X1_96/a_2_6# Gnd nfet w=20 l=2
+  ad=0 pd=0 as=0.22n ps=0.102m
M5315 vdd OAI21X1_96/C OAI21X1_96/Y vdd pfet w=20 l=2
+  ad=0 pd=0 as=0.22n ps=92u
M5316 OAI21X1_96/Y OAI21X1_96/C OAI21X1_96/a_2_6# Gnd nfet w=20 l=2
+  ad=100p pd=50u as=0 ps=0
M5317 OAI21X1_96/Y INVX2_91/Y OAI21X1_96/a_9_54# vdd pfet w=40 l=2
+  ad=0 pd=0 as=0.12n ps=86u
M5318 OAI21X1_96/a_9_54# OAI21X1_97/A vdd vdd pfet w=40 l=2
+  ad=0 pd=0 as=0 ps=0
M5319 OAI21X1_96/a_2_6# INVX2_91/Y gnd Gnd nfet w=20 l=2
+  ad=0 pd=0 as=0 ps=0
M5320 gnd OAI21X1_74/A OAI21X1_74/a_2_6# Gnd nfet w=20 l=2
+  ad=0 pd=0 as=0.22n ps=0.102m
M5321 vdd OAI21X1_74/C OAI21X1_74/Y vdd pfet w=20 l=2
+  ad=0 pd=0 as=0.22n ps=92u
M5322 OAI21X1_74/Y OAI21X1_74/C OAI21X1_74/a_2_6# Gnd nfet w=20 l=2
+  ad=100p pd=50u as=0 ps=0
M5323 OAI21X1_74/Y OAI21X1_91/B OAI21X1_74/a_9_54# vdd pfet w=40 l=2
+  ad=0 pd=0 as=0.12n ps=86u
M5324 OAI21X1_74/a_9_54# OAI21X1_74/A vdd vdd pfet w=40 l=2
+  ad=0 pd=0 as=0 ps=0
M5325 OAI21X1_74/a_2_6# OAI21X1_91/B gnd Gnd nfet w=20 l=2
+  ad=0 pd=0 as=0 ps=0
M5326 gnd OR2X1_9/A OAI21X1_85/a_2_6# Gnd nfet w=20 l=2
+  ad=0 pd=0 as=0.22n ps=0.102m
M5327 vdd INVX2_135/Y OAI21X1_85/Y vdd pfet w=20 l=2
+  ad=0 pd=0 as=0.22n ps=92u
M5328 OAI21X1_85/Y INVX2_135/Y OAI21X1_85/a_2_6# Gnd nfet w=20 l=2
+  ad=100p pd=50u as=0 ps=0
M5329 OAI21X1_85/Y INVX2_60/Y OAI21X1_85/a_9_54# vdd pfet w=40 l=2
+  ad=0 pd=0 as=0.12n ps=86u
M5330 OAI21X1_85/a_9_54# OR2X1_9/A vdd vdd pfet w=40 l=2
+  ad=0 pd=0 as=0 ps=0
M5331 OAI21X1_85/a_2_6# INVX2_60/Y gnd Gnd nfet w=20 l=2
+  ad=0 pd=0 as=0 ps=0
M5332 OR2X1_12/a_2_54# OR2X1_15/A gnd Gnd nfet w=10 l=2
+  ad=59.999996p pd=32u as=0 ps=0
M5333 OR2X1_12/Y OR2X1_12/a_2_54# vdd vdd pfet w=20 l=2
+  ad=100p pd=50u as=0 ps=0
M5334 OR2X1_12/Y OR2X1_12/a_2_54# gnd Gnd nfet w=10 l=2
+  ad=50p pd=30u as=0 ps=0
M5335 vdd OR2X1_12/B OR2X1_12/a_9_54# vdd pfet w=40 l=2
+  ad=0 pd=0 as=0.12n ps=86u
M5336 OR2X1_12/a_9_54# OR2X1_15/A OR2X1_12/a_2_54# vdd pfet w=40 l=2
+  ad=0 pd=0 as=0.2n ps=90u
M5337 gnd OR2X1_12/B OR2X1_12/a_2_54# Gnd nfet w=10 l=2
+  ad=0 pd=0 as=0 ps=0
M5338 AND2X2_22/a_2_6# LATCH_2/Q vdd vdd pfet w=20 l=2
+  ad=0.12n pd=52u as=0 ps=0
M5339 AND2X2_22/a_9_6# LATCH_2/Q AND2X2_22/a_2_6# Gnd nfet w=20 l=2
+  ad=59.999996p pd=46u as=100p ps=50u
M5340 AND2X2_22/Y AND2X2_22/a_2_6# gnd Gnd nfet w=20 l=2
+  ad=100p pd=50u as=0 ps=0
M5341 AND2X2_22/Y AND2X2_22/a_2_6# vdd vdd pfet w=40 l=2
+  ad=0.2n pd=90u as=0 ps=0
M5342 vdd INVX2_165/Y AND2X2_22/a_2_6# vdd pfet w=20 l=2
+  ad=0 pd=0 as=0 ps=0
M5343 gnd INVX2_165/Y AND2X2_22/a_9_6# Gnd nfet w=20 l=2
+  ad=0 pd=0 as=0 ps=0
M5344 AND2X2_11/a_2_6# AND2X2_11/A vdd vdd pfet w=20 l=2
+  ad=0.12n pd=52u as=0 ps=0
M5345 AND2X2_11/a_9_6# AND2X2_11/A AND2X2_11/a_2_6# Gnd nfet w=20 l=2
+  ad=59.999996p pd=46u as=100p ps=50u
M5346 AND2X2_11/Y AND2X2_11/a_2_6# gnd Gnd nfet w=20 l=2
+  ad=100p pd=50u as=0 ps=0
M5347 AND2X2_11/Y AND2X2_11/a_2_6# vdd vdd pfet w=40 l=2
+  ad=0.2n pd=90u as=0 ps=0
M5348 vdd INVX2_178/Y AND2X2_11/a_2_6# vdd pfet w=20 l=2
+  ad=0 pd=0 as=0 ps=0
M5349 gnd INVX2_178/Y AND2X2_11/a_9_6# Gnd nfet w=20 l=2
+  ad=0 pd=0 as=0 ps=0
M5350 OAI21X1_37/C OAI21X1_36/C vdd vdd pfet w=20 l=2
+  ad=0.22n pd=0.102m as=0 ps=0
M5351 NAND3X1_11/a_9_6# OAI21X1_36/C gnd Gnd nfet w=30 l=2
+  ad=90p pd=66u as=0 ps=0
M5352 OAI21X1_37/C HAX1_1/YS vdd vdd pfet w=20 l=2
+  ad=0 pd=0 as=0 ps=0
M5353 OAI21X1_37/C HAX1_1/YS NAND3X1_11/a_14_6# Gnd nfet w=30 l=2
+  ad=0.15n pd=70u as=90p ps=66u
M5354 vdd INVX2_175/Y OAI21X1_37/C vdd pfet w=20 l=2
+  ad=0 pd=0 as=0 ps=0
M5355 NAND3X1_11/a_14_6# INVX2_175/Y NAND3X1_11/a_9_6# Gnd nfet w=30 l=2
+  ad=0 pd=0 as=0 ps=0
M5356 OAI21X1_70/C NAND2X1_1/B vdd vdd pfet w=20 l=2
+  ad=0.22n pd=0.102m as=0 ps=0
M5357 NAND3X1_22/a_9_6# NAND2X1_1/B gnd Gnd nfet w=30 l=2
+  ad=90p pd=66u as=0 ps=0
M5358 OAI21X1_70/C INVX2_28/A vdd vdd pfet w=20 l=2
+  ad=0 pd=0 as=0 ps=0
M5359 OAI21X1_70/C INVX2_28/A NAND3X1_22/a_14_6# Gnd nfet w=30 l=2
+  ad=0.15n pd=70u as=90p ps=66u
M5360 vdd INVX2_27/Y OAI21X1_70/C vdd pfet w=20 l=2
+  ad=0 pd=0 as=0 ps=0
M5361 NAND3X1_22/a_14_6# INVX2_27/Y NAND3X1_22/a_9_6# Gnd nfet w=30 l=2
+  ad=0 pd=0 as=0 ps=0
M5362 INVX2_161/A NAND3X1_44/A vdd vdd pfet w=20 l=2
+  ad=0.22n pd=0.102m as=0 ps=0
M5363 NAND3X1_44/a_9_6# NAND3X1_44/A gnd Gnd nfet w=30 l=2
+  ad=90p pd=66u as=0 ps=0
M5364 INVX2_161/A INVX2_158/A vdd vdd pfet w=20 l=2
+  ad=0 pd=0 as=0 ps=0
M5365 INVX2_161/A INVX2_158/A NAND3X1_44/a_14_6# Gnd nfet w=30 l=2
+  ad=0.15n pd=70u as=90p ps=66u
M5366 vdd NOR2X1_45/A INVX2_161/A vdd pfet w=20 l=2
+  ad=0 pd=0 as=0 ps=0
M5367 NAND3X1_44/a_14_6# NOR2X1_45/A NAND3X1_44/a_9_6# Gnd nfet w=30 l=2
+  ad=0 pd=0 as=0 ps=0
M5368 OAI21X1_91/C INVX2_153/A vdd vdd pfet w=20 l=2
+  ad=0.22n pd=0.102m as=0 ps=0
M5369 NAND3X1_33/a_9_6# INVX2_153/A gnd Gnd nfet w=30 l=2
+  ad=90p pd=66u as=0 ps=0
M5370 OAI21X1_91/C NOR2X1_36/Y vdd vdd pfet w=20 l=2
+  ad=0 pd=0 as=0 ps=0
M5371 OAI21X1_91/C NOR2X1_36/Y NAND3X1_33/a_14_6# Gnd nfet w=30 l=2
+  ad=0.15n pd=70u as=90p ps=66u
M5372 vdd NAND2X1_1/B OAI21X1_91/C vdd pfet w=20 l=2
+  ad=0 pd=0 as=0 ps=0
M5373 NAND3X1_33/a_14_6# NAND2X1_1/B NAND3X1_33/a_9_6# Gnd nfet w=30 l=2
+  ad=0 pd=0 as=0 ps=0
M5374 INVX2_81/A NOR2X1_11/A gnd Gnd nfet w=10 l=2
+  ad=59.999996p pd=32u as=0 ps=0
M5375 INVX2_81/A invader_1_coord_y[3] NOR2X1_11/a_9_54# vdd pfet w=40 l=2
+  ad=0.2n pd=90u as=0.12n ps=86u
M5376 NOR2X1_11/a_9_54# NOR2X1_11/A vdd vdd pfet w=40 l=2
+  ad=0 pd=0 as=0 ps=0
M5377 gnd invader_1_coord_y[3] INVX2_81/A Gnd nfet w=10 l=2
+  ad=0 pd=0 as=0 ps=0
M5378 NOR2X1_44/Y OR2X1_15/A gnd Gnd nfet w=10 l=2
+  ad=59.999996p pd=32u as=0 ps=0
M5379 NOR2X1_44/Y NOR2X1_44/B NOR2X1_44/a_9_54# vdd pfet w=40 l=2
+  ad=0.2n pd=90u as=0.12n ps=86u
M5380 NOR2X1_44/a_9_54# OR2X1_15/A vdd vdd pfet w=40 l=2
+  ad=0 pd=0 as=0 ps=0
M5381 gnd NOR2X1_44/B NOR2X1_44/Y Gnd nfet w=10 l=2
+  ad=0 pd=0 as=0 ps=0
M5382 NOR2X1_55/Y NOR2X1_55/A gnd Gnd nfet w=10 l=2
+  ad=59.999996p pd=32u as=0 ps=0
M5383 NOR2X1_55/Y NOR2X1_55/B NOR2X1_55/a_9_54# vdd pfet w=40 l=2
+  ad=0.2n pd=90u as=0.12n ps=86u
M5384 NOR2X1_55/a_9_54# NOR2X1_55/A vdd vdd pfet w=40 l=2
+  ad=0 pd=0 as=0 ps=0
M5385 gnd NOR2X1_55/B NOR2X1_55/Y Gnd nfet w=10 l=2
+  ad=0 pd=0 as=0 ps=0
M5386 NOR2X1_22/Y INVX2_13/A gnd Gnd nfet w=10 l=2
+  ad=59.999996p pd=32u as=0 ps=0
M5387 NOR2X1_22/Y invader_bullet_coord_y[3] NOR2X1_22/a_9_54# vdd pfet w=40 l=2
+  ad=0.2n pd=90u as=0.12n ps=86u
M5388 NOR2X1_22/a_9_54# INVX2_13/A vdd vdd pfet w=40 l=2
+  ad=0 pd=0 as=0 ps=0
M5389 gnd invader_bullet_coord_y[3] NOR2X1_22/Y Gnd nfet w=10 l=2
+  ad=0 pd=0 as=0 ps=0
M5390 NOR2X1_33/Y INVX2_28/A gnd Gnd nfet w=10 l=2
+  ad=59.999996p pd=32u as=0 ps=0
M5391 NOR2X1_33/Y INVX2_27/A NOR2X1_33/a_9_54# vdd pfet w=40 l=2
+  ad=0.2n pd=90u as=0.12n ps=86u
M5392 NOR2X1_33/a_9_54# INVX2_28/A vdd vdd pfet w=40 l=2
+  ad=0 pd=0 as=0 ps=0
M5393 gnd INVX2_27/A NOR2X1_33/Y Gnd nfet w=10 l=2
+  ad=0 pd=0 as=0 ps=0
M5394 gnd LATCH_2/CLK LATCH_0/a_2_6# Gnd nfet w=20 l=2
+  ad=59.999996p pd=27u as=100p ps=50u
M5395 LATCH_0/a_23_6# LATCH_2/CLK LATCH_0/a_18_6# Gnd nfet w=10 l=2
+  ad=50p pd=20u as=14.999999p ps=13u
M5396 LATCH_0/a_23_6# LATCH_0/a_2_6# LATCH_0/a_18_74# vdd pfet w=20 l=2
+  ad=90p pd=30u as=29.999998p ps=23u
M5397 LATCH_0/Q LATCH_0/a_23_6# gnd Gnd nfet w=20 l=2
+  ad=100p pd=50u as=59.999996p ps=27u
M5398 LATCH_0/a_35_6# LATCH_0/a_2_6# LATCH_0/a_23_6# Gnd nfet w=10 l=2
+  ad=14.999999p pd=13u as=50p ps=20u
M5399 LATCH_0/a_18_6# LATCH_0/D gnd Gnd nfet w=10 l=2
+  ad=14.999999p pd=13u as=59.999996p ps=27u
M5400 vdd LATCH_2/CLK LATCH_0/a_2_6# vdd pfet w=40 l=2
+  ad=0.12n pd=47u as=0.2n ps=90u
M5401 vdd LATCH_0/Q LATCH_0/a_35_84# vdd pfet w=10 l=2
+  ad=0.11n pd=47u as=14.999999p ps=13u
M5402 LATCH_0/a_18_74# LATCH_0/D vdd vdd pfet w=20 l=2
+  ad=29.999998p pd=23u as=0.12n ps=47u
M5403 LATCH_0/Q LATCH_0/a_23_6# vdd vdd pfet w=40 l=2
+  ad=0.2n pd=90u as=0.11n ps=47u
M5404 gnd LATCH_0/Q LATCH_0/a_35_6# Gnd nfet w=10 l=2
+  ad=59.999996p pd=27u as=14.999999p ps=13u
M5405 LATCH_0/a_35_84# LATCH_2/CLK LATCH_0/a_23_6# vdd pfet w=10 l=2
+  ad=14.999999p pd=13u as=90p ps=30u
M5406 INVX2_90/Y shield_coord_y[2] gnd Gnd nfet w=20 l=2
+  ad=100p pd=50u as=0 ps=0
M5407 INVX2_90/Y shield_coord_y[2] vdd vdd pfet w=40 l=2
+  ad=0.2n pd=90u as=0 ps=0
M5408 gnd INVX2_68/Y OAI21X1_20/a_2_6# Gnd nfet w=20 l=2
+  ad=0 pd=0 as=0.22n ps=0.102m
M5409 vdd NAND3X1_6/Y INVX2_69/A vdd pfet w=20 l=2
+  ad=0 pd=0 as=0.22n ps=92u
M5410 INVX2_69/A NAND3X1_6/Y OAI21X1_20/a_2_6# Gnd nfet w=20 l=2
+  ad=100p pd=50u as=0 ps=0
M5411 INVX2_69/A INVX2_18/Y OAI21X1_20/a_9_54# vdd pfet w=40 l=2
+  ad=0 pd=0 as=0.12n ps=86u
M5412 OAI21X1_20/a_9_54# INVX2_68/Y vdd vdd pfet w=40 l=2
+  ad=0 pd=0 as=0 ps=0
M5413 OAI21X1_20/a_2_6# INVX2_18/Y gnd Gnd nfet w=20 l=2
+  ad=0 pd=0 as=0 ps=0
M5414 gnd player_bullet_coord_x[3] OAI21X1_31/a_2_6# Gnd nfet w=20 l=2
+  ad=0 pd=0 as=0.22n ps=0.102m
M5415 vdd OAI21X1_32/Y OAI21X1_31/Y vdd pfet w=20 l=2
+  ad=0 pd=0 as=0.22n ps=92u
M5416 OAI21X1_31/Y OAI21X1_32/Y OAI21X1_31/a_2_6# Gnd nfet w=20 l=2
+  ad=100p pd=50u as=0 ps=0
M5417 OAI21X1_31/Y INVX2_173/A OAI21X1_31/a_9_54# vdd pfet w=40 l=2
+  ad=0 pd=0 as=0.12n ps=86u
M5418 OAI21X1_31/a_9_54# player_bullet_coord_x[3] vdd vdd pfet w=40 l=2
+  ad=0 pd=0 as=0 ps=0
M5419 OAI21X1_31/a_2_6# INVX2_173/A gnd Gnd nfet w=20 l=2
+  ad=0 pd=0 as=0 ps=0
M5420 gnd NAND2X1_1/Y OAI21X1_42/a_2_6# Gnd nfet w=20 l=2
+  ad=0 pd=0 as=0.22n ps=0.102m
M5421 vdd OAI21X1_43/Y OAI21X1_42/Y vdd pfet w=20 l=2
+  ad=0 pd=0 as=0.22n ps=92u
M5422 OAI21X1_42/Y OAI21X1_43/Y OAI21X1_42/a_2_6# Gnd nfet w=20 l=2
+  ad=100p pd=50u as=0 ps=0
M5423 OAI21X1_42/Y INVX2_6/Y OAI21X1_42/a_9_54# vdd pfet w=40 l=2
+  ad=0 pd=0 as=0.12n ps=86u
M5424 OAI21X1_42/a_9_54# NAND2X1_1/Y vdd vdd pfet w=40 l=2
+  ad=0 pd=0 as=0 ps=0
M5425 OAI21X1_42/a_2_6# INVX2_6/Y gnd Gnd nfet w=20 l=2
+  ad=0 pd=0 as=0 ps=0
M5426 gnd INVX2_149/A OAI21X1_53/a_2_6# Gnd nfet w=20 l=2
+  ad=0 pd=0 as=0.22n ps=0.102m
M5427 vdd OAI21X1_53/C OAI21X1_53/Y vdd pfet w=20 l=2
+  ad=0 pd=0 as=0.22n ps=92u
M5428 OAI21X1_53/Y OAI21X1_53/C OAI21X1_53/a_2_6# Gnd nfet w=20 l=2
+  ad=100p pd=50u as=0 ps=0
M5429 OAI21X1_53/Y INVX2_54/Y OAI21X1_53/a_9_54# vdd pfet w=40 l=2
+  ad=0 pd=0 as=0.12n ps=86u
M5430 OAI21X1_53/a_9_54# INVX2_149/A vdd vdd pfet w=40 l=2
+  ad=0 pd=0 as=0 ps=0
M5431 OAI21X1_53/a_2_6# INVX2_54/Y gnd Gnd nfet w=20 l=2
+  ad=0 pd=0 as=0 ps=0
M5432 gnd INVX2_29/Y OAI21X1_64/a_2_6# Gnd nfet w=20 l=2
+  ad=0 pd=0 as=0.22n ps=0.102m
M5433 vdd NOR2X1_31/Y INVX2_148/A vdd pfet w=20 l=2
+  ad=0 pd=0 as=0.22n ps=92u
M5434 INVX2_148/A NOR2X1_31/Y OAI21X1_64/a_2_6# Gnd nfet w=20 l=2
+  ad=100p pd=50u as=0 ps=0
M5435 INVX2_148/A INVX2_144/Y OAI21X1_64/a_9_54# vdd pfet w=40 l=2
+  ad=0 pd=0 as=0.12n ps=86u
M5436 OAI21X1_64/a_9_54# INVX2_29/Y vdd vdd pfet w=40 l=2
+  ad=0 pd=0 as=0 ps=0
M5437 OAI21X1_64/a_2_6# INVX2_144/Y gnd Gnd nfet w=20 l=2
+  ad=0 pd=0 as=0 ps=0
M5438 gnd AND2X2_14/B OAI21X1_86/a_2_6# Gnd nfet w=20 l=2
+  ad=0 pd=0 as=0.22n ps=0.102m
M5439 vdd OAI21X1_87/Y OAI21X1_86/Y vdd pfet w=20 l=2
+  ad=0 pd=0 as=0.22n ps=92u
M5440 OAI21X1_86/Y OAI21X1_87/Y OAI21X1_86/a_2_6# Gnd nfet w=20 l=2
+  ad=100p pd=50u as=0 ps=0
M5441 OAI21X1_86/Y INVX2_55/Y OAI21X1_86/a_9_54# vdd pfet w=40 l=2
+  ad=0 pd=0 as=0.12n ps=86u
M5442 OAI21X1_86/a_9_54# AND2X2_14/B vdd vdd pfet w=40 l=2
+  ad=0 pd=0 as=0 ps=0
M5443 OAI21X1_86/a_2_6# INVX2_55/Y gnd Gnd nfet w=20 l=2
+  ad=0 pd=0 as=0 ps=0
M5444 gnd INVX2_57/Y OAI21X1_75/a_2_6# Gnd nfet w=20 l=2
+  ad=0 pd=0 as=0.22n ps=0.102m
M5445 vdd OAI21X1_75/C OAI21X1_75/Y vdd pfet w=20 l=2
+  ad=0 pd=0 as=0.22n ps=92u
M5446 OAI21X1_75/Y OAI21X1_75/C OAI21X1_75/a_2_6# Gnd nfet w=20 l=2
+  ad=100p pd=50u as=0 ps=0
M5447 OAI21X1_75/Y OAI22X1_5/B OAI21X1_75/a_9_54# vdd pfet w=40 l=2
+  ad=0 pd=0 as=0.12n ps=86u
M5448 OAI21X1_75/a_9_54# INVX2_57/Y vdd vdd pfet w=40 l=2
+  ad=0 pd=0 as=0 ps=0
M5449 OAI21X1_75/a_2_6# OAI22X1_5/B gnd Gnd nfet w=20 l=2
+  ad=0 pd=0 as=0 ps=0
M5450 gnd OAI21X1_97/A OAI21X1_97/a_2_6# Gnd nfet w=20 l=2
+  ad=0 pd=0 as=0.22n ps=0.102m
M5451 vdd INVX2_133/Y OAI21X1_97/Y vdd pfet w=20 l=2
+  ad=0 pd=0 as=0.22n ps=92u
M5452 OAI21X1_97/Y INVX2_133/Y OAI21X1_97/a_2_6# Gnd nfet w=20 l=2
+  ad=100p pd=50u as=0 ps=0
M5453 OAI21X1_97/Y INVX2_90/Y OAI21X1_97/a_9_54# vdd pfet w=40 l=2
+  ad=0 pd=0 as=0.12n ps=86u
M5454 OAI21X1_97/a_9_54# OAI21X1_97/A vdd vdd pfet w=40 l=2
+  ad=0 pd=0 as=0 ps=0
M5455 OAI21X1_97/a_2_6# INVX2_90/Y gnd Gnd nfet w=20 l=2
+  ad=0 pd=0 as=0 ps=0
M5456 OR2X1_13/a_2_54# OR2X1_13/A gnd Gnd nfet w=10 l=2
+  ad=59.999996p pd=32u as=0 ps=0
M5457 OR2X1_13/Y OR2X1_13/a_2_54# vdd vdd pfet w=20 l=2
+  ad=100p pd=50u as=0 ps=0
M5458 OR2X1_13/Y OR2X1_13/a_2_54# gnd Gnd nfet w=10 l=2
+  ad=50p pd=30u as=0 ps=0
M5459 vdd OR2X1_13/B OR2X1_13/a_9_54# vdd pfet w=40 l=2
+  ad=0 pd=0 as=0.12n ps=86u
M5460 OR2X1_13/a_9_54# OR2X1_13/A OR2X1_13/a_2_54# vdd pfet w=40 l=2
+  ad=0 pd=0 as=0.2n ps=90u
M5461 gnd OR2X1_13/B OR2X1_13/a_2_54# Gnd nfet w=10 l=2
+  ad=0 pd=0 as=0 ps=0
M5462 AND2X2_12/a_2_6# AND2X2_8/A vdd vdd pfet w=20 l=2
+  ad=0.12n pd=52u as=0 ps=0
M5463 AND2X2_12/a_9_6# AND2X2_8/A AND2X2_12/a_2_6# Gnd nfet w=20 l=2
+  ad=59.999996p pd=46u as=100p ps=50u
M5464 AND2X2_12/Y AND2X2_12/a_2_6# gnd Gnd nfet w=20 l=2
+  ad=100p pd=50u as=0 ps=0
M5465 AND2X2_12/Y AND2X2_12/a_2_6# vdd vdd pfet w=40 l=2
+  ad=0.2n pd=90u as=0 ps=0
M5466 vdd AND2X2_14/Y AND2X2_12/a_2_6# vdd pfet w=20 l=2
+  ad=0 pd=0 as=0 ps=0
M5467 gnd AND2X2_14/Y AND2X2_12/a_9_6# Gnd nfet w=20 l=2
+  ad=0 pd=0 as=0 ps=0
M5468 AND2X2_23/a_2_6# AND2X2_25/B vdd vdd pfet w=20 l=2
+  ad=0.12n pd=52u as=0 ps=0
M5469 AND2X2_23/a_9_6# AND2X2_25/B AND2X2_23/a_2_6# Gnd nfet w=20 l=2
+  ad=59.999996p pd=46u as=100p ps=50u
M5470 LATCH_0/D AND2X2_23/a_2_6# gnd Gnd nfet w=20 l=2
+  ad=100p pd=50u as=0 ps=0
M5471 LATCH_0/D AND2X2_23/a_2_6# vdd vdd pfet w=40 l=2
+  ad=0.2n pd=90u as=0 ps=0
M5472 vdd player_shoot_input AND2X2_23/a_2_6# vdd pfet w=20 l=2
+  ad=0 pd=0 as=0 ps=0
M5473 gnd player_shoot_input AND2X2_23/a_9_6# Gnd nfet w=20 l=2
+  ad=0 pd=0 as=0 ps=0
M5474 vdd invader_bullet_coord_x[3] HAX1_0/a_2_74# vdd pfet w=20 l=2
+  ad=0 pd=0 as=0.2n ps=100u
M5475 HAX1_0/a_41_74# HAX1_0/a_2_74# vdd vdd pfet w=20 l=2
+  ad=0.22n pd=92u as=0 ps=0
M5476 HAX1_0/a_9_6# invader_bullet_coord_x[3] gnd Gnd nfet w=20 l=2
+  ad=59.999996p pd=46u as=0 ps=0
M5477 HAX1_0/a_41_74# HAX1_0/B HAX1_0/a_38_6# Gnd nfet w=20 l=2
+  ad=0.12n pd=52u as=0.216n ps=0.102m
M5478 vdd invader_bullet_coord_x[3] HAX1_0/a_49_54# vdd pfet w=40 l=2
+  ad=0 pd=0 as=0.12n ps=86u
M5479 vdd HAX1_0/a_2_74# OR2X1_5/B vdd pfet w=20 l=2
+  ad=0 pd=0 as=100p ps=50u
M5480 HAX1_0/a_38_6# HAX1_0/a_2_74# gnd Gnd nfet w=20 l=2
+  ad=0 pd=0 as=0 ps=0
M5481 INVX2_9/A HAX1_0/a_41_74# vdd vdd pfet w=20 l=2
+  ad=100p pd=50u as=0 ps=0
M5482 HAX1_0/a_38_6# invader_bullet_coord_x[3] HAX1_0/a_41_74# Gnd nfet w=20 l=2
+  ad=0 pd=0 as=0 ps=0
M5483 INVX2_9/A HAX1_0/a_41_74# gnd Gnd nfet w=10 l=2
+  ad=50p pd=30u as=0 ps=0
M5484 HAX1_0/a_2_74# HAX1_0/B vdd vdd pfet w=20 l=2
+  ad=0 pd=0 as=0 ps=0
M5485 HAX1_0/a_2_74# HAX1_0/B HAX1_0/a_9_6# Gnd nfet w=20 l=2
+  ad=100p pd=50u as=0 ps=0
M5486 HAX1_0/a_49_54# HAX1_0/B HAX1_0/a_41_74# vdd pfet w=40 l=2
+  ad=0 pd=0 as=0 ps=0
M5487 gnd HAX1_0/a_2_74# OR2X1_5/B Gnd nfet w=10 l=2
+  ad=0 pd=0 as=50p ps=30u
M5488 OAI21X1_40/C NAND2X1_1/Y vdd vdd pfet w=20 l=2
+  ad=0.22n pd=0.102m as=0 ps=0
M5489 NAND3X1_12/a_9_6# NAND2X1_1/Y gnd Gnd nfet w=30 l=2
+  ad=90p pd=66u as=0 ps=0
M5490 OAI21X1_40/C OAI22X1_7/Y vdd vdd pfet w=20 l=2
+  ad=0 pd=0 as=0 ps=0
M5491 OAI21X1_40/C OAI22X1_7/Y NAND3X1_12/a_14_6# Gnd nfet w=30 l=2
+  ad=0.15n pd=70u as=90p ps=66u
M5492 vdd NAND2X1_1/B OAI21X1_40/C vdd pfet w=20 l=2
+  ad=0 pd=0 as=0 ps=0
M5493 NAND3X1_12/a_14_6# NAND2X1_1/B NAND3X1_12/a_9_6# Gnd nfet w=30 l=2
+  ad=0 pd=0 as=0 ps=0
M5494 OAI21X1_71/C INVX2_153/A vdd vdd pfet w=20 l=2
+  ad=0.22n pd=0.102m as=0 ps=0
M5495 NAND3X1_23/a_9_6# INVX2_153/A gnd Gnd nfet w=30 l=2
+  ad=90p pd=66u as=0 ps=0
M5496 OAI21X1_71/C NOR2X1_33/Y vdd vdd pfet w=20 l=2
+  ad=0 pd=0 as=0 ps=0
M5497 OAI21X1_71/C NOR2X1_33/Y NAND3X1_23/a_14_6# Gnd nfet w=30 l=2
+  ad=0.15n pd=70u as=90p ps=66u
M5498 vdd NAND2X1_1/B OAI21X1_71/C vdd pfet w=20 l=2
+  ad=0 pd=0 as=0 ps=0
M5499 NAND3X1_23/a_14_6# NAND2X1_1/B NAND3X1_23/a_9_6# Gnd nfet w=30 l=2
+  ad=0 pd=0 as=0 ps=0
M5500 INVX2_166/A INVX2_165/Y vdd vdd pfet w=20 l=2
+  ad=0.22n pd=0.102m as=0 ps=0
M5501 NAND3X1_45/a_9_6# INVX2_165/Y gnd Gnd nfet w=30 l=2
+  ad=90p pd=66u as=0 ps=0
M5502 INVX2_166/A INVX2_125/A vdd vdd pfet w=20 l=2
+  ad=0 pd=0 as=0 ps=0
M5503 INVX2_166/A INVX2_125/A NAND3X1_45/a_14_6# Gnd nfet w=30 l=2
+  ad=0.15n pd=70u as=90p ps=66u
M5504 vdd NOR2X1_59/A INVX2_166/A vdd pfet w=20 l=2
+  ad=0 pd=0 as=0 ps=0
M5505 NAND3X1_45/a_14_6# NOR2X1_59/A NAND3X1_45/a_9_6# Gnd nfet w=30 l=2
+  ad=0 pd=0 as=0 ps=0
M5506 OAI21X1_91/B NAND2X1_1/B vdd vdd pfet w=20 l=2
+  ad=0.22n pd=0.102m as=0 ps=0
M5507 NAND3X1_34/a_9_6# NAND2X1_1/B gnd Gnd nfet w=30 l=2
+  ad=90p pd=66u as=0 ps=0
M5508 OAI21X1_91/B INVX2_57/A vdd vdd pfet w=20 l=2
+  ad=0 pd=0 as=0 ps=0
M5509 OAI21X1_91/B INVX2_57/A NAND3X1_34/a_14_6# Gnd nfet w=30 l=2
+  ad=0.15n pd=70u as=90p ps=66u
M5510 vdd INVX2_58/Y OAI21X1_91/B vdd pfet w=20 l=2
+  ad=0 pd=0 as=0 ps=0
M5511 NAND3X1_34/a_14_6# INVX2_58/Y NAND3X1_34/a_9_6# Gnd nfet w=30 l=2
+  ad=0 pd=0 as=0 ps=0
M5512 NOR2X1_12/Y invader_1_coord_y[1] gnd Gnd nfet w=10 l=2
+  ad=59.999996p pd=32u as=0 ps=0
M5513 NOR2X1_12/Y invader_1_coord_y[0] NOR2X1_12/a_9_54# vdd pfet w=40 l=2
+  ad=0.2n pd=90u as=0.12n ps=86u
M5514 NOR2X1_12/a_9_54# invader_1_coord_y[1] vdd vdd pfet w=40 l=2
+  ad=0 pd=0 as=0 ps=0
M5515 gnd invader_1_coord_y[0] NOR2X1_12/Y Gnd nfet w=10 l=2
+  ad=0 pd=0 as=0 ps=0
M5516 NOR2X1_45/Y NOR2X1_45/A gnd Gnd nfet w=10 l=2
+  ad=59.999996p pd=32u as=0 ps=0
M5517 NOR2X1_45/Y NOR2X1_45/B NOR2X1_45/a_9_54# vdd pfet w=40 l=2
+  ad=0.2n pd=90u as=0.12n ps=86u
M5518 NOR2X1_45/a_9_54# NOR2X1_45/A vdd vdd pfet w=40 l=2
+  ad=0 pd=0 as=0 ps=0
M5519 gnd NOR2X1_45/B NOR2X1_45/Y Gnd nfet w=10 l=2
+  ad=0 pd=0 as=0 ps=0
M5520 NOR2X1_23/Y player_bullet_coord_y[3] gnd Gnd nfet w=10 l=2
+  ad=59.999996p pd=32u as=0 ps=0
M5521 NOR2X1_23/Y NOR2X1_23/B NOR2X1_23/a_9_54# vdd pfet w=40 l=2
+  ad=0.2n pd=90u as=0.12n ps=86u
M5522 NOR2X1_23/a_9_54# player_bullet_coord_y[3] vdd vdd pfet w=40 l=2
+  ad=0 pd=0 as=0 ps=0
M5523 gnd NOR2X1_23/B NOR2X1_23/Y Gnd nfet w=10 l=2
+  ad=0 pd=0 as=0 ps=0
M5524 NOR2X1_34/Y INVX2_59/Y gnd Gnd nfet w=10 l=2
+  ad=59.999996p pd=32u as=0 ps=0
M5525 NOR2X1_34/Y OR2X1_15/A NOR2X1_34/a_9_54# vdd pfet w=40 l=2
+  ad=0.2n pd=90u as=0.12n ps=86u
M5526 NOR2X1_34/a_9_54# INVX2_59/Y vdd vdd pfet w=40 l=2
+  ad=0 pd=0 as=0 ps=0
M5527 gnd OR2X1_15/A NOR2X1_34/Y Gnd nfet w=10 l=2
+  ad=0 pd=0 as=0 ps=0
M5528 NOR2X1_56/Y NOR2X1_56/A gnd Gnd nfet w=10 l=2
+  ad=59.999996p pd=32u as=0 ps=0
M5529 NOR2X1_56/Y NOR2X1_56/B NOR2X1_56/a_9_54# vdd pfet w=40 l=2
+  ad=0.2n pd=90u as=0.12n ps=86u
M5530 NOR2X1_56/a_9_54# NOR2X1_56/A vdd vdd pfet w=40 l=2
+  ad=0 pd=0 as=0 ps=0
M5531 gnd NOR2X1_56/B NOR2X1_56/Y Gnd nfet w=10 l=2
+  ad=0 pd=0 as=0 ps=0
M5532 gnd LATCH_2/CLK LATCH_1/a_2_6# Gnd nfet w=20 l=2
+  ad=0 pd=0 as=100p ps=50u
M5533 LATCH_1/a_23_6# LATCH_2/CLK LATCH_1/a_18_6# Gnd nfet w=10 l=2
+  ad=100p pd=40u as=29.999998p ps=26u
M5534 LATCH_1/a_23_6# LATCH_1/a_2_6# LATCH_1/a_18_74# vdd pfet w=20 l=2
+  ad=0.18n pd=60u as=59.999996p ps=46u
M5535 LATCH_1/Q LATCH_1/a_23_6# gnd Gnd nfet w=20 l=2
+  ad=100p pd=50u as=0 ps=0
M5536 LATCH_1/a_35_6# LATCH_1/a_2_6# LATCH_1/a_23_6# Gnd nfet w=10 l=2
+  ad=29.999998p pd=26u as=0 ps=0
M5537 LATCH_1/a_18_6# LATCH_1/D gnd Gnd nfet w=10 l=2
+  ad=0 pd=0 as=0 ps=0
M5538 vdd LATCH_2/CLK LATCH_1/a_2_6# vdd pfet w=40 l=2
+  ad=0 pd=0 as=0.2n ps=90u
M5539 vdd LATCH_1/Q LATCH_1/a_35_84# vdd pfet w=10 l=2
+  ad=0 pd=0 as=29.999998p ps=26u
M5540 LATCH_1/a_18_74# LATCH_1/D vdd vdd pfet w=20 l=2
+  ad=0 pd=0 as=0 ps=0
M5541 LATCH_1/Q LATCH_1/a_23_6# vdd vdd pfet w=40 l=2
+  ad=0.2n pd=90u as=0 ps=0
M5542 gnd LATCH_1/Q LATCH_1/a_35_6# Gnd nfet w=10 l=2
+  ad=0 pd=0 as=0 ps=0
M5543 LATCH_1/a_35_84# LATCH_2/CLK LATCH_1/a_23_6# vdd pfet w=10 l=2
+  ad=0 pd=0 as=0 ps=0
M5544 INVX2_91/Y shield_coord_y[0] gnd Gnd nfet w=20 l=2
+  ad=100p pd=50u as=0 ps=0
M5545 INVX2_91/Y shield_coord_y[0] vdd vdd pfet w=40 l=2
+  ad=0.2n pd=90u as=0 ps=0
M5546 INVX2_80/Y INVX2_80/A gnd Gnd nfet w=20 l=2
+  ad=100p pd=50u as=0 ps=0
M5547 INVX2_80/Y INVX2_80/A vdd vdd pfet w=40 l=2
+  ad=0.2n pd=90u as=0 ps=0
M5548 gnd INVX2_42/A OAI21X1_10/a_2_6# Gnd nfet w=20 l=2
+  ad=0 pd=0 as=0.22n ps=0.102m
M5549 vdd INVX2_43/Y AOI21X1_8/C vdd pfet w=20 l=2
+  ad=0 pd=0 as=0.22n ps=92u
M5550 AOI21X1_8/C INVX2_43/Y OAI21X1_10/a_2_6# Gnd nfet w=20 l=2
+  ad=100p pd=50u as=0 ps=0
M5551 AOI21X1_8/C OAI21X1_11/Y OAI21X1_10/a_9_54# vdd pfet w=40 l=2
+  ad=0 pd=0 as=0.12n ps=86u
M5552 OAI21X1_10/a_9_54# INVX2_42/A vdd vdd pfet w=40 l=2
+  ad=0 pd=0 as=0 ps=0
M5553 OAI21X1_10/a_2_6# OAI21X1_11/Y gnd Gnd nfet w=20 l=2
+  ad=0 pd=0 as=0 ps=0
M5554 gnd INVX2_173/Y OAI21X1_32/a_2_6# Gnd nfet w=20 l=2
+  ad=0 pd=0 as=0.22n ps=0.102m
M5555 vdd OAI21X1_32/C OAI21X1_32/Y vdd pfet w=20 l=2
+  ad=0 pd=0 as=0.22n ps=92u
M5556 OAI21X1_32/Y OAI21X1_32/C OAI21X1_32/a_2_6# Gnd nfet w=20 l=2
+  ad=100p pd=50u as=0 ps=0
M5557 OAI21X1_32/Y INVX2_18/Y OAI21X1_32/a_9_54# vdd pfet w=40 l=2
+  ad=0 pd=0 as=0.12n ps=86u
M5558 OAI21X1_32/a_9_54# INVX2_173/Y vdd vdd pfet w=40 l=2
+  ad=0 pd=0 as=0 ps=0
M5559 OAI21X1_32/a_2_6# INVX2_18/Y gnd Gnd nfet w=20 l=2
+  ad=0 pd=0 as=0 ps=0
M5560 gnd HAX1_7/YS OAI21X1_21/a_2_6# Gnd nfet w=20 l=2
+  ad=0 pd=0 as=0.22n ps=0.102m
M5561 vdd NAND3X1_7/A AOI22X1_6/D vdd pfet w=20 l=2
+  ad=0 pd=0 as=0.22n ps=92u
M5562 AOI22X1_6/D NAND3X1_7/A OAI21X1_21/a_2_6# Gnd nfet w=20 l=2
+  ad=100p pd=50u as=0 ps=0
M5563 AOI22X1_6/D INVX2_15/Y OAI21X1_21/a_9_54# vdd pfet w=40 l=2
+  ad=0 pd=0 as=0.12n ps=86u
M5564 OAI21X1_21/a_9_54# HAX1_7/YS vdd vdd pfet w=40 l=2
+  ad=0 pd=0 as=0 ps=0
M5565 OAI21X1_21/a_2_6# INVX2_15/Y gnd Gnd nfet w=20 l=2
+  ad=0 pd=0 as=0 ps=0
M5566 gnd INVX2_115/Y OAI21X1_43/a_2_6# Gnd nfet w=20 l=2
+  ad=0 pd=0 as=0.22n ps=0.102m
M5567 vdd NAND2X1_1/Y OAI21X1_43/Y vdd pfet w=20 l=2
+  ad=0 pd=0 as=0.22n ps=92u
M5568 OAI21X1_43/Y NAND2X1_1/Y OAI21X1_43/a_2_6# Gnd nfet w=20 l=2
+  ad=100p pd=50u as=0 ps=0
M5569 OAI21X1_43/Y OR2X1_15/A OAI21X1_43/a_9_54# vdd pfet w=40 l=2
+  ad=0 pd=0 as=0.12n ps=86u
M5570 OAI21X1_43/a_9_54# INVX2_115/Y vdd vdd pfet w=40 l=2
+  ad=0 pd=0 as=0 ps=0
M5571 OAI21X1_43/a_2_6# OR2X1_15/A gnd Gnd nfet w=20 l=2
+  ad=0 pd=0 as=0 ps=0
M5572 gnd invader_2_coord_x[1] OAI21X1_54/a_2_6# Gnd nfet w=20 l=2
+  ad=0 pd=0 as=0.22n ps=0.102m
M5573 vdd invader_2_coord_x[2] AND2X2_7/A vdd pfet w=20 l=2
+  ad=0 pd=0 as=0.22n ps=92u
M5574 AND2X2_7/A invader_2_coord_x[2] OAI21X1_54/a_2_6# Gnd nfet w=20 l=2
+  ad=100p pd=50u as=0 ps=0
M5575 AND2X2_7/A invader_2_coord_x[0] OAI21X1_54/a_9_54# vdd pfet w=40 l=2
+  ad=0 pd=0 as=0.12n ps=86u
M5576 OAI21X1_54/a_9_54# invader_2_coord_x[1] vdd vdd pfet w=40 l=2
+  ad=0 pd=0 as=0 ps=0
M5577 OAI21X1_54/a_2_6# invader_2_coord_x[0] gnd Gnd nfet w=20 l=2
+  ad=0 pd=0 as=0 ps=0
M5578 gnd OR2X1_8/B OAI21X1_65/a_2_6# Gnd nfet w=20 l=2
+  ad=0 pd=0 as=0.22n ps=0.102m
M5579 vdd INVX2_138/Y OAI21X1_65/Y vdd pfet w=20 l=2
+  ad=0 pd=0 as=0.22n ps=92u
M5580 OAI21X1_65/Y INVX2_138/Y OAI21X1_65/a_2_6# Gnd nfet w=20 l=2
+  ad=100p pd=50u as=0 ps=0
M5581 OAI21X1_65/Y INVX2_33/Y OAI21X1_65/a_9_54# vdd pfet w=40 l=2
+  ad=0 pd=0 as=0.12n ps=86u
M5582 OAI21X1_65/a_9_54# OR2X1_8/B vdd vdd pfet w=40 l=2
+  ad=0 pd=0 as=0 ps=0
M5583 OAI21X1_65/a_2_6# INVX2_33/Y gnd Gnd nfet w=20 l=2
+  ad=0 pd=0 as=0 ps=0
M5584 gnd OR2X1_9/A OAI21X1_87/a_2_6# Gnd nfet w=20 l=2
+  ad=0 pd=0 as=0.22n ps=0.102m
M5585 vdd AND2X2_14/B OAI21X1_87/Y vdd pfet w=20 l=2
+  ad=0 pd=0 as=0.22n ps=92u
M5586 OAI21X1_87/Y AND2X2_14/B OAI21X1_87/a_2_6# Gnd nfet w=20 l=2
+  ad=100p pd=50u as=0 ps=0
M5587 OAI21X1_87/Y INVX2_156/Y OAI21X1_87/a_9_54# vdd pfet w=40 l=2
+  ad=0 pd=0 as=0.12n ps=86u
M5588 OAI21X1_87/a_9_54# OR2X1_9/A vdd vdd pfet w=40 l=2
+  ad=0 pd=0 as=0 ps=0
M5589 OAI21X1_87/a_2_6# INVX2_156/Y gnd Gnd nfet w=20 l=2
+  ad=0 pd=0 as=0 ps=0
M5590 gnd OAI22X1_5/B OAI21X1_76/a_2_6# Gnd nfet w=20 l=2
+  ad=0 pd=0 as=0.22n ps=0.102m
M5591 vdd OAI21X1_76/C OAI21X1_76/Y vdd pfet w=20 l=2
+  ad=0 pd=0 as=0.22n ps=92u
M5592 OAI21X1_76/Y OAI21X1_76/C OAI21X1_76/a_2_6# Gnd nfet w=20 l=2
+  ad=100p pd=50u as=0 ps=0
M5593 OAI21X1_76/Y INVX2_58/Y OAI21X1_76/a_9_54# vdd pfet w=40 l=2
+  ad=0 pd=0 as=0.12n ps=86u
M5594 OAI21X1_76/a_9_54# OAI22X1_5/B vdd vdd pfet w=40 l=2
+  ad=0 pd=0 as=0 ps=0
M5595 OAI21X1_76/a_2_6# INVX2_58/Y gnd Gnd nfet w=20 l=2
+  ad=0 pd=0 as=0 ps=0
M5596 gnd INVX2_89/A OAI21X1_98/a_2_6# Gnd nfet w=20 l=2
+  ad=0 pd=0 as=0.22n ps=0.102m
M5597 vdd OAI21X1_99/B OAI21X1_98/Y vdd pfet w=20 l=2
+  ad=0 pd=0 as=0.22n ps=92u
M5598 OAI21X1_98/Y OAI21X1_99/B OAI21X1_98/a_2_6# Gnd nfet w=20 l=2
+  ad=100p pd=50u as=0 ps=0
M5599 OAI21X1_98/Y INVX2_85/Y OAI21X1_98/a_9_54# vdd pfet w=40 l=2
+  ad=0 pd=0 as=0.12n ps=86u
M5600 OAI21X1_98/a_9_54# INVX2_89/A vdd vdd pfet w=40 l=2
+  ad=0 pd=0 as=0 ps=0
M5601 OAI21X1_98/a_2_6# INVX2_85/Y gnd Gnd nfet w=20 l=2
+  ad=0 pd=0 as=0 ps=0
M5602 OR2X1_14/a_2_54# OR2X1_14/A gnd Gnd nfet w=10 l=2
+  ad=59.999996p pd=32u as=0 ps=0
M5603 OR2X1_14/Y OR2X1_14/a_2_54# vdd vdd pfet w=20 l=2
+  ad=100p pd=50u as=0 ps=0
M5604 OR2X1_14/Y OR2X1_14/a_2_54# gnd Gnd nfet w=10 l=2
+  ad=50p pd=30u as=0 ps=0
M5605 vdd OR2X1_14/B OR2X1_14/a_9_54# vdd pfet w=40 l=2
+  ad=0 pd=0 as=0.12n ps=86u
M5606 OR2X1_14/a_9_54# OR2X1_14/A OR2X1_14/a_2_54# vdd pfet w=40 l=2
+  ad=0 pd=0 as=0.2n ps=90u
M5607 gnd OR2X1_14/B OR2X1_14/a_2_54# Gnd nfet w=10 l=2
+  ad=0 pd=0 as=0 ps=0
M5608 AND2X2_13/a_2_6# AND2X2_14/Y vdd vdd pfet w=20 l=2
+  ad=0.12n pd=52u as=0 ps=0
M5609 AND2X2_13/a_9_6# AND2X2_14/Y AND2X2_13/a_2_6# Gnd nfet w=20 l=2
+  ad=59.999996p pd=46u as=100p ps=50u
M5610 AND2X2_13/Y AND2X2_13/a_2_6# gnd Gnd nfet w=20 l=2
+  ad=100p pd=50u as=0 ps=0
M5611 AND2X2_13/Y AND2X2_13/a_2_6# vdd vdd pfet w=40 l=2
+  ad=0.2n pd=90u as=0 ps=0
M5612 vdd AND2X2_9/B AND2X2_13/a_2_6# vdd pfet w=20 l=2
+  ad=0 pd=0 as=0 ps=0
M5613 gnd AND2X2_9/B AND2X2_13/a_9_6# Gnd nfet w=20 l=2
+  ad=0 pd=0 as=0 ps=0
M5614 AND2X2_24/a_2_6# player_right_input vdd vdd pfet w=20 l=2
+  ad=0.12n pd=52u as=0 ps=0
M5615 AND2X2_24/a_9_6# player_right_input AND2X2_24/a_2_6# Gnd nfet w=20 l=2
+  ad=59.999996p pd=46u as=100p ps=50u
M5616 LATCH_1/D AND2X2_24/a_2_6# gnd Gnd nfet w=20 l=2
+  ad=100p pd=50u as=0 ps=0
M5617 LATCH_1/D AND2X2_24/a_2_6# vdd vdd pfet w=40 l=2
+  ad=0.2n pd=90u as=0 ps=0
M5618 vdd AND2X2_25/B AND2X2_24/a_2_6# vdd pfet w=20 l=2
+  ad=0 pd=0 as=0 ps=0
M5619 gnd AND2X2_25/B AND2X2_24/a_9_6# Gnd nfet w=20 l=2
+  ad=0 pd=0 as=0 ps=0
M5620 vdd invader_bullet_coord_x[2] HAX1_1/a_2_74# vdd pfet w=20 l=2
+  ad=0 pd=0 as=0.2n ps=100u
M5621 HAX1_1/a_41_74# HAX1_1/a_2_74# vdd vdd pfet w=20 l=2
+  ad=0.22n pd=92u as=0 ps=0
M5622 HAX1_1/a_9_6# invader_bullet_coord_x[2] gnd Gnd nfet w=20 l=2
+  ad=59.999996p pd=46u as=0 ps=0
M5623 HAX1_1/a_41_74# HAX1_1/B HAX1_1/a_38_6# Gnd nfet w=20 l=2
+  ad=0.12n pd=52u as=0.216n ps=0.102m
M5624 vdd invader_bullet_coord_x[2] HAX1_1/a_49_54# vdd pfet w=40 l=2
+  ad=0 pd=0 as=0.12n ps=86u
M5625 vdd HAX1_1/a_2_74# HAX1_0/B vdd pfet w=20 l=2
+  ad=0 pd=0 as=100p ps=50u
M5626 HAX1_1/a_38_6# HAX1_1/a_2_74# gnd Gnd nfet w=20 l=2
+  ad=0 pd=0 as=0 ps=0
M5627 HAX1_1/YS HAX1_1/a_41_74# vdd vdd pfet w=20 l=2
+  ad=100p pd=50u as=0 ps=0
M5628 HAX1_1/a_38_6# invader_bullet_coord_x[2] HAX1_1/a_41_74# Gnd nfet w=20 l=2
+  ad=0 pd=0 as=0 ps=0
M5629 HAX1_1/YS HAX1_1/a_41_74# gnd Gnd nfet w=10 l=2
+  ad=50p pd=30u as=0 ps=0
M5630 HAX1_1/a_2_74# HAX1_1/B vdd vdd pfet w=20 l=2
+  ad=0 pd=0 as=0 ps=0
M5631 HAX1_1/a_2_74# HAX1_1/B HAX1_1/a_9_6# Gnd nfet w=20 l=2
+  ad=100p pd=50u as=0 ps=0
M5632 HAX1_1/a_49_54# HAX1_1/B HAX1_1/a_41_74# vdd pfet w=40 l=2
+  ad=0 pd=0 as=0 ps=0
M5633 gnd HAX1_1/a_2_74# HAX1_0/B Gnd nfet w=10 l=2
+  ad=0 pd=0 as=50p ps=30u
M5634 OAI21X1_41/C NAND2X1_1/Y vdd vdd pfet w=20 l=2
+  ad=0.22n pd=0.102m as=0 ps=0
M5635 NAND3X1_13/a_9_6# NAND2X1_1/Y gnd Gnd nfet w=30 l=2
+  ad=90p pd=66u as=0 ps=0
M5636 OAI21X1_41/C OAI22X1_6/Y vdd vdd pfet w=20 l=2
+  ad=0 pd=0 as=0 ps=0
M5637 OAI21X1_41/C OAI22X1_6/Y NAND3X1_13/a_14_6# Gnd nfet w=30 l=2
+  ad=0.15n pd=70u as=90p ps=66u
M5638 vdd NAND2X1_1/B OAI21X1_41/C vdd pfet w=20 l=2
+  ad=0 pd=0 as=0 ps=0
M5639 NAND3X1_13/a_14_6# NAND2X1_1/B NAND3X1_13/a_9_6# Gnd nfet w=30 l=2
+  ad=0 pd=0 as=0 ps=0
M5640 NAND3X1_46/Y INVX2_124/Y vdd vdd pfet w=20 l=2
+  ad=0.22n pd=0.102m as=0 ps=0
M5641 NAND3X1_46/a_9_6# INVX2_124/Y gnd Gnd nfet w=30 l=2
+  ad=90p pd=66u as=0 ps=0
M5642 NAND3X1_46/Y player_shoot_input vdd vdd pfet w=20 l=2
+  ad=0 pd=0 as=0 ps=0
M5643 NAND3X1_46/Y player_shoot_input NAND3X1_46/a_14_6# Gnd nfet w=30 l=2
+  ad=0.15n pd=70u as=90p ps=66u
M5644 vdd INVX2_150/Y NAND3X1_46/Y vdd pfet w=20 l=2
+  ad=0 pd=0 as=0 ps=0
M5645 NAND3X1_46/a_14_6# INVX2_150/Y NAND3X1_46/a_9_6# Gnd nfet w=30 l=2
+  ad=0 pd=0 as=0 ps=0
M5646 INVX2_82/A NAND3X1_35/A vdd vdd pfet w=20 l=2
+  ad=0.22n pd=0.102m as=0 ps=0
M5647 NAND3X1_35/a_9_6# NAND3X1_35/A gnd Gnd nfet w=30 l=2
+  ad=90p pd=66u as=0 ps=0
M5648 INVX2_82/A AND2X2_15/Y vdd vdd pfet w=20 l=2
+  ad=0 pd=0 as=0 ps=0
M5649 INVX2_82/A AND2X2_15/Y NAND3X1_35/a_14_6# Gnd nfet w=30 l=2
+  ad=0.15n pd=70u as=90p ps=66u
M5650 vdd OR2X1_3/Y INVX2_82/A vdd pfet w=20 l=2
+  ad=0 pd=0 as=0 ps=0
M5651 NAND3X1_35/a_14_6# OR2X1_3/Y NAND3X1_35/a_9_6# Gnd nfet w=30 l=2
+  ad=0 pd=0 as=0 ps=0
M5652 OAI21X1_71/B NAND2X1_1/B vdd vdd pfet w=20 l=2
+  ad=0.22n pd=0.102m as=0 ps=0
M5653 NAND3X1_24/a_9_6# NAND2X1_1/B gnd Gnd nfet w=30 l=2
+  ad=90p pd=66u as=0 ps=0
M5654 OAI21X1_71/B INVX2_27/A vdd vdd pfet w=20 l=2
+  ad=0 pd=0 as=0 ps=0
M5655 OAI21X1_71/B INVX2_27/A NAND3X1_24/a_14_6# Gnd nfet w=30 l=2
+  ad=0.15n pd=70u as=90p ps=66u
M5656 vdd INVX2_28/Y OAI21X1_71/B vdd pfet w=20 l=2
+  ad=0 pd=0 as=0 ps=0
M5657 NAND3X1_24/a_14_6# INVX2_28/Y NAND3X1_24/a_9_6# Gnd nfet w=30 l=2
+  ad=0 pd=0 as=0 ps=0
M5658 NOR2X1_46/Y player_coord_x[3] gnd Gnd nfet w=10 l=2
+  ad=59.999996p pd=32u as=0 ps=0
M5659 NOR2X1_46/Y player_coord_x[2] NOR2X1_46/a_9_54# vdd pfet w=40 l=2
+  ad=0.2n pd=90u as=0.12n ps=86u
M5660 NOR2X1_46/a_9_54# player_coord_x[3] vdd vdd pfet w=40 l=2
+  ad=0 pd=0 as=0 ps=0
M5661 gnd player_coord_x[2] NOR2X1_46/Y Gnd nfet w=10 l=2
+  ad=0 pd=0 as=0 ps=0
M5662 NOR2X1_13/Y AND2X2_2/Y gnd Gnd nfet w=10 l=2
+  ad=59.999996p pd=32u as=0 ps=0
M5663 NOR2X1_13/Y XOR2X1_2/Y NOR2X1_13/a_9_54# vdd pfet w=40 l=2
+  ad=0.2n pd=90u as=0.12n ps=86u
M5664 NOR2X1_13/a_9_54# AND2X2_2/Y vdd vdd pfet w=40 l=2
+  ad=0 pd=0 as=0 ps=0
M5665 gnd XOR2X1_2/Y NOR2X1_13/Y Gnd nfet w=10 l=2
+  ad=0 pd=0 as=0 ps=0
M5666 NOR2X1_24/Y INVX2_22/Y gnd Gnd nfet w=10 l=2
+  ad=59.999996p pd=32u as=0 ps=0
M5667 NOR2X1_24/Y INVX2_14/Y NOR2X1_24/a_9_54# vdd pfet w=40 l=2
+  ad=0.2n pd=90u as=0.12n ps=86u
M5668 NOR2X1_24/a_9_54# INVX2_22/Y vdd vdd pfet w=40 l=2
+  ad=0 pd=0 as=0 ps=0
M5669 gnd INVX2_14/Y NOR2X1_24/Y Gnd nfet w=10 l=2
+  ad=0 pd=0 as=0 ps=0
M5670 INVX2_59/A INVX2_56/Y gnd Gnd nfet w=10 l=2
+  ad=59.999996p pd=32u as=0 ps=0
M5671 INVX2_59/A NOR2X1_35/B NOR2X1_35/a_9_54# vdd pfet w=40 l=2
+  ad=0.2n pd=90u as=0.12n ps=86u
M5672 NOR2X1_35/a_9_54# INVX2_56/Y vdd vdd pfet w=40 l=2
+  ad=0 pd=0 as=0 ps=0
M5673 gnd NOR2X1_35/B INVX2_59/A Gnd nfet w=10 l=2
+  ad=0 pd=0 as=0 ps=0
M5674 NOR2X1_57/Y NOR2X1_57/A gnd Gnd nfet w=10 l=2
+  ad=59.999996p pd=32u as=0 ps=0
M5675 NOR2X1_57/Y NOR2X1_57/B NOR2X1_57/a_9_54# vdd pfet w=40 l=2
+  ad=0.2n pd=90u as=0.12n ps=86u
M5676 NOR2X1_57/a_9_54# NOR2X1_57/A vdd vdd pfet w=40 l=2
+  ad=0 pd=0 as=0 ps=0
M5677 gnd NOR2X1_57/B NOR2X1_57/Y Gnd nfet w=10 l=2
+  ad=0 pd=0 as=0 ps=0
M5678 gnd LATCH_2/CLK LATCH_2/a_2_6# Gnd nfet w=20 l=2
+  ad=0 pd=0 as=100p ps=50u
M5679 LATCH_2/a_23_6# LATCH_2/CLK LATCH_2/a_18_6# Gnd nfet w=10 l=2
+  ad=100p pd=40u as=29.999998p ps=26u
M5680 LATCH_2/a_23_6# LATCH_2/a_2_6# LATCH_2/a_18_74# vdd pfet w=20 l=2
+  ad=0.18n pd=60u as=59.999996p ps=46u
M5681 LATCH_2/Q LATCH_2/a_23_6# gnd Gnd nfet w=20 l=2
+  ad=100p pd=50u as=0 ps=0
M5682 LATCH_2/a_35_6# LATCH_2/a_2_6# LATCH_2/a_23_6# Gnd nfet w=10 l=2
+  ad=29.999998p pd=26u as=0 ps=0
M5683 LATCH_2/a_18_6# LATCH_2/D gnd Gnd nfet w=10 l=2
+  ad=0 pd=0 as=0 ps=0
M5684 vdd LATCH_2/CLK LATCH_2/a_2_6# vdd pfet w=40 l=2
+  ad=0 pd=0 as=0.2n ps=90u
M5685 vdd LATCH_2/Q LATCH_2/a_35_84# vdd pfet w=10 l=2
+  ad=0 pd=0 as=29.999998p ps=26u
M5686 LATCH_2/a_18_74# LATCH_2/D vdd vdd pfet w=20 l=2
+  ad=0 pd=0 as=0 ps=0
M5687 LATCH_2/Q LATCH_2/a_23_6# vdd vdd pfet w=40 l=2
+  ad=0.2n pd=90u as=0 ps=0
M5688 gnd LATCH_2/Q LATCH_2/a_35_6# Gnd nfet w=10 l=2
+  ad=0 pd=0 as=0 ps=0
M5689 LATCH_2/a_35_84# LATCH_2/CLK LATCH_2/a_23_6# vdd pfet w=10 l=2
+  ad=0 pd=0 as=0 ps=0
M5690 INVX2_81/Y INVX2_81/A gnd Gnd nfet w=20 l=2
+  ad=100p pd=50u as=0 ps=0
M5691 INVX2_81/Y INVX2_81/A vdd vdd pfet w=40 l=2
+  ad=0.2n pd=90u as=0 ps=0
M5692 INVX2_70/Y NOR2X1_9/Y gnd Gnd nfet w=20 l=2
+  ad=100p pd=50u as=0 ps=0
M5693 INVX2_70/Y NOR2X1_9/Y vdd vdd pfet w=40 l=2
+  ad=0.2n pd=90u as=0 ps=0
M5694 INVX2_92/Y shield_coord_x[2] gnd Gnd nfet w=20 l=2
+  ad=100p pd=50u as=0 ps=0
M5695 INVX2_92/Y shield_coord_x[2] vdd vdd pfet w=40 l=2
+  ad=0.2n pd=90u as=0 ps=0
M5696 gnd INVX2_35/Y OAI21X1_11/a_2_6# Gnd nfet w=20 l=2
+  ad=0 pd=0 as=0.22n ps=0.102m
M5697 vdd OAI22X1_1/Y OAI21X1_11/Y vdd pfet w=20 l=2
+  ad=0 pd=0 as=0.22n ps=92u
M5698 OAI21X1_11/Y OAI22X1_1/Y OAI21X1_11/a_2_6# Gnd nfet w=20 l=2
+  ad=100p pd=50u as=0 ps=0
M5699 OAI21X1_11/Y INVX2_22/Y OAI21X1_11/a_9_54# vdd pfet w=40 l=2
+  ad=0 pd=0 as=0.12n ps=86u
M5700 OAI21X1_11/a_9_54# INVX2_35/Y vdd vdd pfet w=40 l=2
+  ad=0 pd=0 as=0 ps=0
M5701 OAI21X1_11/a_2_6# INVX2_22/Y gnd Gnd nfet w=20 l=2
+  ad=0 pd=0 as=0 ps=0
M5702 gnd shield_coord_x[1] OAI21X1_33/a_2_6# Gnd nfet w=20 l=2
+  ad=0 pd=0 as=0.22n ps=0.102m
M5703 vdd INVX2_21/Y OAI21X1_33/Y vdd pfet w=20 l=2
+  ad=0 pd=0 as=0.22n ps=92u
M5704 OAI21X1_33/Y INVX2_21/Y OAI21X1_33/a_2_6# Gnd nfet w=20 l=2
+  ad=100p pd=50u as=0 ps=0
M5705 OAI21X1_33/Y player_bullet_coord_x[1] OAI21X1_33/a_9_54# vdd pfet w=40 l=2
+  ad=0 pd=0 as=0.12n ps=86u
M5706 OAI21X1_33/a_9_54# shield_coord_x[1] vdd vdd pfet w=40 l=2
+  ad=0 pd=0 as=0 ps=0
M5707 OAI21X1_33/a_2_6# player_bullet_coord_x[1] gnd Gnd nfet w=20 l=2
+  ad=0 pd=0 as=0 ps=0
M5708 gnd player_bullet_coord_y[3] OAI21X1_22/a_2_6# Gnd nfet w=20 l=2
+  ad=0 pd=0 as=0.22n ps=0.102m
M5709 vdd NAND3X1_7/Y INVX2_78/A vdd pfet w=20 l=2
+  ad=0 pd=0 as=0.22n ps=92u
M5710 INVX2_78/A NAND3X1_7/Y OAI21X1_22/a_2_6# Gnd nfet w=20 l=2
+  ad=100p pd=50u as=0 ps=0
M5711 INVX2_78/A INVX2_77/Y OAI21X1_22/a_9_54# vdd pfet w=40 l=2
+  ad=0 pd=0 as=0.12n ps=86u
M5712 OAI21X1_22/a_9_54# player_bullet_coord_y[3] vdd vdd pfet w=40 l=2
+  ad=0 pd=0 as=0 ps=0
M5713 OAI21X1_22/a_2_6# INVX2_77/Y gnd Gnd nfet w=20 l=2
+  ad=0 pd=0 as=0 ps=0
M5714 gnd NAND2X1_1/Y OAI21X1_44/a_2_6# Gnd nfet w=20 l=2
+  ad=0 pd=0 as=0.22n ps=0.102m
M5715 vdd OAI21X1_45/Y OAI21X1_44/Y vdd pfet w=20 l=2
+  ad=0 pd=0 as=0.22n ps=92u
M5716 OAI21X1_44/Y OAI21X1_45/Y OAI21X1_44/a_2_6# Gnd nfet w=20 l=2
+  ad=100p pd=50u as=0 ps=0
M5717 OAI21X1_44/Y INVX2_7/Y OAI21X1_44/a_9_54# vdd pfet w=40 l=2
+  ad=0 pd=0 as=0.12n ps=86u
M5718 OAI21X1_44/a_9_54# NAND2X1_1/Y vdd vdd pfet w=40 l=2
+  ad=0 pd=0 as=0 ps=0
M5719 OAI21X1_44/a_2_6# INVX2_7/Y gnd Gnd nfet w=20 l=2
+  ad=0 pd=0 as=0 ps=0
M5720 gnd INVX2_149/A OAI21X1_66/a_2_6# Gnd nfet w=20 l=2
+  ad=0 pd=0 as=0.22n ps=0.102m
M5721 vdd OAI21X1_67/Y OAI21X1_66/Y vdd pfet w=20 l=2
+  ad=0 pd=0 as=0.22n ps=92u
M5722 OAI21X1_66/Y OAI21X1_67/Y OAI21X1_66/a_2_6# Gnd nfet w=20 l=2
+  ad=100p pd=50u as=0 ps=0
M5723 OAI21X1_66/Y INVX2_25/Y OAI21X1_66/a_9_54# vdd pfet w=40 l=2
+  ad=0 pd=0 as=0.12n ps=86u
M5724 OAI21X1_66/a_9_54# INVX2_149/A vdd vdd pfet w=40 l=2
+  ad=0 pd=0 as=0 ps=0
M5725 OAI21X1_66/a_2_6# INVX2_25/Y gnd Gnd nfet w=20 l=2
+  ad=0 pd=0 as=0 ps=0
M5726 gnd INVX2_30/A OAI21X1_55/a_2_6# Gnd nfet w=20 l=2
+  ad=0 pd=0 as=0.22n ps=0.102m
M5727 vdd OAI21X1_55/C OAI21X1_55/Y vdd pfet w=20 l=2
+  ad=0 pd=0 as=0.22n ps=92u
M5728 OAI21X1_55/Y OAI21X1_55/C OAI21X1_55/a_2_6# Gnd nfet w=20 l=2
+  ad=100p pd=50u as=0 ps=0
M5729 OAI21X1_55/Y OAI21X1_71/B OAI21X1_55/a_9_54# vdd pfet w=40 l=2
+  ad=0 pd=0 as=0.12n ps=86u
M5730 OAI21X1_55/a_9_54# INVX2_30/A vdd vdd pfet w=40 l=2
+  ad=0 pd=0 as=0 ps=0
M5731 OAI21X1_55/a_2_6# OAI21X1_71/B gnd Gnd nfet w=20 l=2
+  ad=0 pd=0 as=0 ps=0
M5732 gnd AND2X2_14/B OAI21X1_77/a_2_6# Gnd nfet w=20 l=2
+  ad=0 pd=0 as=0.22n ps=0.102m
M5733 vdd OAI21X1_77/C OAI21X1_77/Y vdd pfet w=20 l=2
+  ad=0 pd=0 as=0.22n ps=92u
M5734 OAI21X1_77/Y OAI21X1_77/C OAI21X1_77/a_2_6# Gnd nfet w=20 l=2
+  ad=100p pd=50u as=0 ps=0
M5735 OAI21X1_77/Y INVX2_178/Y OAI21X1_77/a_9_54# vdd pfet w=40 l=2
+  ad=0 pd=0 as=0.12n ps=86u
M5736 OAI21X1_77/a_9_54# AND2X2_14/B vdd vdd pfet w=40 l=2
+  ad=0 pd=0 as=0 ps=0
M5737 OAI21X1_77/a_2_6# INVX2_178/Y gnd Gnd nfet w=20 l=2
+  ad=0 pd=0 as=0 ps=0
M5738 gnd INVX2_85/Y OAI21X1_99/a_2_6# Gnd nfet w=20 l=2
+  ad=0 pd=0 as=0.22n ps=0.102m
M5739 vdd INVX2_134/A OR2X1_11/B vdd pfet w=20 l=2
+  ad=0 pd=0 as=0.22n ps=92u
M5740 OR2X1_11/B INVX2_134/A OAI21X1_99/a_2_6# Gnd nfet w=20 l=2
+  ad=100p pd=50u as=0 ps=0
M5741 OR2X1_11/B OAI21X1_99/B OAI21X1_99/a_9_54# vdd pfet w=40 l=2
+  ad=0 pd=0 as=0.12n ps=86u
M5742 OAI21X1_99/a_9_54# INVX2_85/Y vdd vdd pfet w=40 l=2
+  ad=0 pd=0 as=0 ps=0
M5743 OAI21X1_99/a_2_6# OAI21X1_99/B gnd Gnd nfet w=20 l=2
+  ad=0 pd=0 as=0 ps=0
M5744 gnd INVX2_61/Y OAI21X1_88/a_2_6# Gnd nfet w=20 l=2
+  ad=0 pd=0 as=0.22n ps=0.102m
M5745 vdd INVX2_136/Y AND2X2_14/B vdd pfet w=20 l=2
+  ad=0 pd=0 as=0.22n ps=92u
M5746 AND2X2_14/B INVX2_136/Y OAI21X1_88/a_2_6# Gnd nfet w=20 l=2
+  ad=100p pd=50u as=0 ps=0
M5747 AND2X2_14/B OAI21X1_88/B OAI21X1_88/a_9_54# vdd pfet w=40 l=2
+  ad=0 pd=0 as=0.12n ps=86u
M5748 OAI21X1_88/a_9_54# INVX2_61/Y vdd vdd pfet w=40 l=2
+  ad=0 pd=0 as=0 ps=0
M5749 OAI21X1_88/a_2_6# OAI21X1_88/B gnd Gnd nfet w=20 l=2
+  ad=0 pd=0 as=0 ps=0
M5750 OR2X1_15/a_2_54# OR2X1_15/A gnd Gnd nfet w=10 l=2
+  ad=59.999996p pd=32u as=0 ps=0
M5751 OR2X1_15/Y OR2X1_15/a_2_54# vdd vdd pfet w=20 l=2
+  ad=100p pd=50u as=0 ps=0
M5752 OR2X1_15/Y OR2X1_15/a_2_54# gnd Gnd nfet w=10 l=2
+  ad=50p pd=30u as=0 ps=0
M5753 vdd OR2X1_15/B OR2X1_15/a_9_54# vdd pfet w=40 l=2
+  ad=0 pd=0 as=0.12n ps=86u
M5754 OR2X1_15/a_9_54# OR2X1_15/A OR2X1_15/a_2_54# vdd pfet w=40 l=2
+  ad=0 pd=0 as=0.2n ps=90u
M5755 gnd OR2X1_15/B OR2X1_15/a_2_54# Gnd nfet w=10 l=2
+  ad=0 pd=0 as=0 ps=0
M5756 AND2X2_25/a_2_6# player_left_input vdd vdd pfet w=20 l=2
+  ad=0.12n pd=52u as=0 ps=0
M5757 AND2X2_25/a_9_6# player_left_input AND2X2_25/a_2_6# Gnd nfet w=20 l=2
+  ad=59.999996p pd=46u as=100p ps=50u
M5758 LATCH_2/D AND2X2_25/a_2_6# gnd Gnd nfet w=20 l=2
+  ad=100p pd=50u as=0 ps=0
M5759 LATCH_2/D AND2X2_25/a_2_6# vdd vdd pfet w=40 l=2
+  ad=0.2n pd=90u as=0 ps=0
M5760 vdd AND2X2_25/B AND2X2_25/a_2_6# vdd pfet w=20 l=2
+  ad=0 pd=0 as=0 ps=0
M5761 gnd AND2X2_25/B AND2X2_25/a_9_6# Gnd nfet w=20 l=2
+  ad=0 pd=0 as=0 ps=0
M5762 AND2X2_14/a_2_6# NOR2X1_34/Y vdd vdd pfet w=20 l=2
+  ad=0.12n pd=52u as=0 ps=0
M5763 AND2X2_14/a_9_6# NOR2X1_34/Y AND2X2_14/a_2_6# Gnd nfet w=20 l=2
+  ad=59.999996p pd=46u as=100p ps=50u
M5764 AND2X2_14/Y AND2X2_14/a_2_6# gnd Gnd nfet w=20 l=2
+  ad=100p pd=50u as=0 ps=0
M5765 AND2X2_14/Y AND2X2_14/a_2_6# vdd vdd pfet w=40 l=2
+  ad=0.2n pd=90u as=0 ps=0
M5766 vdd AND2X2_14/B AND2X2_14/a_2_6# vdd pfet w=20 l=2
+  ad=0 pd=0 as=0 ps=0
M5767 gnd AND2X2_14/B AND2X2_14/a_9_6# Gnd nfet w=20 l=2
+  ad=0 pd=0 as=0 ps=0
M5768 vdd invader_bullet_coord_x[1] HAX1_2/a_2_74# vdd pfet w=20 l=2
+  ad=0 pd=0 as=0.2n ps=100u
M5769 HAX1_2/a_41_74# HAX1_2/a_2_74# vdd vdd pfet w=20 l=2
+  ad=0.22n pd=92u as=0 ps=0
M5770 HAX1_2/a_9_6# invader_bullet_coord_x[1] gnd Gnd nfet w=20 l=2
+  ad=59.999996p pd=46u as=0 ps=0
M5771 HAX1_2/a_41_74# invader_bullet_coord_x[0] HAX1_2/a_38_6# Gnd nfet w=20 l=2
+  ad=0.12n pd=52u as=0.216n ps=0.102m
M5772 vdd invader_bullet_coord_x[1] HAX1_2/a_49_54# vdd pfet w=40 l=2
+  ad=0 pd=0 as=0.12n ps=86u
M5773 vdd HAX1_2/a_2_74# HAX1_1/B vdd pfet w=20 l=2
+  ad=0 pd=0 as=100p ps=50u
M5774 HAX1_2/a_38_6# HAX1_2/a_2_74# gnd Gnd nfet w=20 l=2
+  ad=0 pd=0 as=0 ps=0
M5775 INVX2_8/A HAX1_2/a_41_74# vdd vdd pfet w=20 l=2
+  ad=100p pd=50u as=0 ps=0
M5776 HAX1_2/a_38_6# invader_bullet_coord_x[1] HAX1_2/a_41_74# Gnd nfet w=20 l=2
+  ad=0 pd=0 as=0 ps=0
M5777 INVX2_8/A HAX1_2/a_41_74# gnd Gnd nfet w=10 l=2
+  ad=50p pd=30u as=0 ps=0
M5778 HAX1_2/a_2_74# invader_bullet_coord_x[0] vdd vdd pfet w=20 l=2
+  ad=0 pd=0 as=0 ps=0
M5779 HAX1_2/a_2_74# invader_bullet_coord_x[0] HAX1_2/a_9_6# Gnd nfet w=20 l=2
+  ad=100p pd=50u as=0 ps=0
M5780 HAX1_2/a_49_54# invader_bullet_coord_x[0] HAX1_2/a_41_74# vdd pfet w=40 l=2
+  ad=0 pd=0 as=0 ps=0
M5781 gnd HAX1_2/a_2_74# HAX1_1/B Gnd nfet w=10 l=2
+  ad=0 pd=0 as=50p ps=30u
M5782 INVX2_13/A INVX2_0/Y vdd vdd pfet w=20 l=2
+  ad=0.22n pd=0.102m as=0 ps=0
M5783 NAND3X1_14/a_9_6# INVX2_0/Y gnd Gnd nfet w=30 l=2
+  ad=90p pd=66u as=0 ps=0
M5784 INVX2_13/A XNOR2X1_0/Y vdd vdd pfet w=20 l=2
+  ad=0 pd=0 as=0 ps=0
M5785 INVX2_13/A XNOR2X1_0/Y NAND3X1_14/a_14_6# Gnd nfet w=30 l=2
+  ad=0.15n pd=70u as=90p ps=66u
M5786 vdd INVX2_12/Y INVX2_13/A vdd pfet w=20 l=2
+  ad=0 pd=0 as=0 ps=0
M5787 NAND3X1_14/a_14_6# INVX2_12/Y NAND3X1_14/a_9_6# Gnd nfet w=30 l=2
+  ad=0 pd=0 as=0 ps=0
M5788 NOR2X1_55/A INVX2_83/Y vdd vdd pfet w=20 l=2
+  ad=0.22n pd=0.102m as=0 ps=0
M5789 NAND3X1_47/a_9_6# INVX2_83/Y gnd Gnd nfet w=30 l=2
+  ad=90p pd=66u as=0 ps=0
M5790 NOR2X1_55/A INVX2_123/Y vdd vdd pfet w=20 l=2
+  ad=0 pd=0 as=0 ps=0
M5791 NOR2X1_55/A INVX2_123/Y NAND3X1_47/a_14_6# Gnd nfet w=30 l=2
+  ad=0.15n pd=70u as=90p ps=66u
M5792 vdd INVX2_126/Y NOR2X1_55/A vdd pfet w=20 l=2
+  ad=0 pd=0 as=0 ps=0
M5793 NAND3X1_47/a_14_6# INVX2_126/Y NAND3X1_47/a_9_6# Gnd nfet w=30 l=2
+  ad=0 pd=0 as=0 ps=0
M5794 OAI21X1_92/B INVX2_22/Y vdd vdd pfet w=20 l=2
+  ad=0.22n pd=0.102m as=0 ps=0
M5795 NAND3X1_36/a_9_6# INVX2_22/Y gnd Gnd nfet w=30 l=2
+  ad=90p pd=66u as=0 ps=0
M5796 OAI21X1_92/B NOR2X1_37/Y vdd vdd pfet w=20 l=2
+  ad=0 pd=0 as=0 ps=0
M5797 OAI21X1_92/B NOR2X1_37/Y NAND3X1_36/a_14_6# Gnd nfet w=30 l=2
+  ad=0.15n pd=70u as=90p ps=66u
M5798 vdd XOR2X1_10/Y OAI21X1_92/B vdd pfet w=20 l=2
+  ad=0 pd=0 as=0 ps=0
M5799 NAND3X1_36/a_14_6# XOR2X1_10/Y NAND3X1_36/a_9_6# Gnd nfet w=30 l=2
+  ad=0 pd=0 as=0 ps=0
M5800 INVX2_53/A AOI21X1_8/Y vdd vdd pfet w=20 l=2
+  ad=0.22n pd=0.102m as=0 ps=0
M5801 NAND3X1_25/a_9_6# AOI21X1_8/Y gnd Gnd nfet w=30 l=2
+  ad=90p pd=66u as=0 ps=0
M5802 INVX2_53/A AND2X2_10/Y vdd vdd pfet w=20 l=2
+  ad=0 pd=0 as=0 ps=0
M5803 INVX2_53/A AND2X2_10/Y NAND3X1_25/a_14_6# Gnd nfet w=30 l=2
+  ad=0.15n pd=70u as=90p ps=66u
M5804 vdd OR2X1_1/Y INVX2_53/A vdd pfet w=20 l=2
+  ad=0 pd=0 as=0 ps=0
M5805 NAND3X1_25/a_14_6# OR2X1_1/Y NAND3X1_25/a_9_6# Gnd nfet w=30 l=2
+  ad=0 pd=0 as=0 ps=0
M5806 NOR2X1_25/Y player_bullet_coord_y[0] gnd Gnd nfet w=10 l=2
+  ad=59.999996p pd=32u as=0 ps=0
M5807 NOR2X1_25/Y INVX2_16/Y NOR2X1_25/a_9_54# vdd pfet w=40 l=2
+  ad=0.2n pd=90u as=0.12n ps=86u
M5808 NOR2X1_25/a_9_54# player_bullet_coord_y[0] vdd vdd pfet w=40 l=2
+  ad=0 pd=0 as=0 ps=0
M5809 gnd INVX2_16/Y NOR2X1_25/Y Gnd nfet w=10 l=2
+  ad=0 pd=0 as=0 ps=0
M5810 NOR2X1_14/Y AND2X2_1/Y gnd Gnd nfet w=10 l=2
+  ad=59.999996p pd=32u as=0 ps=0
M5811 NOR2X1_14/Y XOR2X1_0/Y NOR2X1_14/a_9_54# vdd pfet w=40 l=2
+  ad=0.2n pd=90u as=0.12n ps=86u
M5812 NOR2X1_14/a_9_54# AND2X2_1/Y vdd vdd pfet w=40 l=2
+  ad=0 pd=0 as=0 ps=0
M5813 gnd XOR2X1_0/Y NOR2X1_14/Y Gnd nfet w=10 l=2
+  ad=0 pd=0 as=0 ps=0
M5814 NOR2X1_36/Y INVX2_58/A gnd Gnd nfet w=10 l=2
+  ad=59.999996p pd=32u as=0 ps=0
M5815 NOR2X1_36/Y INVX2_57/A NOR2X1_36/a_9_54# vdd pfet w=40 l=2
+  ad=0.2n pd=90u as=0.12n ps=86u
M5816 NOR2X1_36/a_9_54# INVX2_58/A vdd vdd pfet w=40 l=2
+  ad=0 pd=0 as=0 ps=0
M5817 gnd INVX2_57/A NOR2X1_36/Y Gnd nfet w=10 l=2
+  ad=0 pd=0 as=0 ps=0
M5818 NOR2X1_47/Y NOR2X1_48/A gnd Gnd nfet w=10 l=2
+  ad=59.999996p pd=32u as=0 ps=0
M5819 NOR2X1_47/Y INVX2_98/Y NOR2X1_47/a_9_54# vdd pfet w=40 l=2
+  ad=0.2n pd=90u as=0.12n ps=86u
M5820 NOR2X1_47/a_9_54# NOR2X1_48/A vdd vdd pfet w=40 l=2
+  ad=0 pd=0 as=0 ps=0
M5821 gnd INVX2_98/Y NOR2X1_47/Y Gnd nfet w=10 l=2
+  ad=0 pd=0 as=0 ps=0
M5822 INVX2_83/A INVX2_84/A gnd Gnd nfet w=10 l=2
+  ad=59.999996p pd=32u as=0 ps=0
M5823 INVX2_83/A INVX2_54/A NOR2X1_58/a_9_54# vdd pfet w=40 l=2
+  ad=0.2n pd=90u as=0.12n ps=86u
M5824 NOR2X1_58/a_9_54# INVX2_84/A vdd vdd pfet w=40 l=2
+  ad=0 pd=0 as=0 ps=0
M5825 gnd INVX2_54/A INVX2_83/A Gnd nfet w=10 l=2
+  ad=0 pd=0 as=0 ps=0
M5826 INVX2_100/A player_coord_x[0] vdd vdd pfet w=20 l=2
+  ad=0.12n pd=52u as=0 ps=0
M5827 NAND2X1_80/a_9_6# player_coord_x[0] gnd Gnd nfet w=20 l=2
+  ad=59.999996p pd=46u as=0 ps=0
M5828 vdd INVX2_55/Y INVX2_100/A vdd pfet w=20 l=2
+  ad=0 pd=0 as=0 ps=0
M5829 INVX2_100/A INVX2_55/Y NAND2X1_80/a_9_6# Gnd nfet w=20 l=2
+  ad=100p pd=50u as=0 ps=0
M5830 INVX2_71/Y invader_1_coord_y[1] gnd Gnd nfet w=20 l=2
+  ad=100p pd=50u as=0 ps=0
M5831 INVX2_71/Y invader_1_coord_y[1] vdd vdd pfet w=40 l=2
+  ad=0.2n pd=90u as=0 ps=0
M5832 INVX2_82/Y INVX2_82/A gnd Gnd nfet w=20 l=2
+  ad=100p pd=50u as=0 ps=0
M5833 INVX2_82/Y INVX2_82/A vdd vdd pfet w=40 l=2
+  ad=0.2n pd=90u as=0 ps=0
M5834 INVX2_60/Y invader_1_display gnd Gnd nfet w=20 l=2
+  ad=100p pd=50u as=0 ps=0
M5835 INVX2_60/Y invader_1_display vdd vdd pfet w=40 l=2
+  ad=0.2n pd=90u as=0 ps=0
M5836 INVX2_93/Y shield_coord_x[1] gnd Gnd nfet w=20 l=2
+  ad=100p pd=50u as=0 ps=0
M5837 INVX2_93/Y shield_coord_x[1] vdd vdd pfet w=40 l=2
+  ad=0.2n pd=90u as=0 ps=0
M5838 gnd HAX1_4/YS OAI21X1_34/a_2_6# Gnd nfet w=20 l=2
+  ad=0 pd=0 as=0.22n ps=0.102m
M5839 vdd OAI21X1_34/C OAI21X1_34/Y vdd pfet w=20 l=2
+  ad=0 pd=0 as=0.22n ps=92u
M5840 OAI21X1_34/Y OAI21X1_34/C OAI21X1_34/a_2_6# Gnd nfet w=20 l=2
+  ad=100p pd=50u as=0 ps=0
M5841 OAI21X1_34/Y INVX2_4/Y OAI21X1_34/a_9_54# vdd pfet w=40 l=2
+  ad=0 pd=0 as=0.12n ps=86u
M5842 OAI21X1_34/a_9_54# HAX1_4/YS vdd vdd pfet w=40 l=2
+  ad=0 pd=0 as=0 ps=0
M5843 OAI21X1_34/a_2_6# INVX2_4/Y gnd Gnd nfet w=20 l=2
+  ad=0 pd=0 as=0 ps=0
M5844 gnd OAI22X1_8/Y OAI21X1_45/a_2_6# Gnd nfet w=20 l=2
+  ad=0 pd=0 as=0.22n ps=0.102m
M5845 vdd NAND2X1_1/Y OAI21X1_45/Y vdd pfet w=20 l=2
+  ad=0 pd=0 as=0.22n ps=92u
M5846 OAI21X1_45/Y NAND2X1_1/Y OAI21X1_45/a_2_6# Gnd nfet w=20 l=2
+  ad=100p pd=50u as=0 ps=0
M5847 OAI21X1_45/Y OR2X1_15/A OAI21X1_45/a_9_54# vdd pfet w=40 l=2
+  ad=0 pd=0 as=0.12n ps=86u
M5848 OAI21X1_45/a_9_54# OAI22X1_8/Y vdd vdd pfet w=40 l=2
+  ad=0 pd=0 as=0 ps=0
M5849 OAI21X1_45/a_2_6# OR2X1_15/A gnd Gnd nfet w=20 l=2
+  ad=0 pd=0 as=0 ps=0
M5850 gnd player_bullet_coord_y[2] OAI21X1_12/a_2_6# Gnd nfet w=20 l=2
+  ad=0 pd=0 as=0.22n ps=0.102m
M5851 vdd NAND3X1_3/A AOI21X1_8/B vdd pfet w=20 l=2
+  ad=0 pd=0 as=0.22n ps=92u
M5852 AOI21X1_8/B NAND3X1_3/A OAI21X1_12/a_2_6# Gnd nfet w=20 l=2
+  ad=100p pd=50u as=0 ps=0
M5853 AOI21X1_8/B INVX2_37/Y OAI21X1_12/a_9_54# vdd pfet w=40 l=2
+  ad=0 pd=0 as=0.12n ps=86u
M5854 OAI21X1_12/a_9_54# player_bullet_coord_y[2] vdd vdd pfet w=40 l=2
+  ad=0 pd=0 as=0 ps=0
M5855 OAI21X1_12/a_2_6# INVX2_37/Y gnd Gnd nfet w=20 l=2
+  ad=0 pd=0 as=0 ps=0
M5856 gnd NOR2X1_12/Y OAI21X1_23/a_2_6# Gnd nfet w=20 l=2
+  ad=0 pd=0 as=0.22n ps=0.102m
M5857 vdd NOR2X1_11/A INVX2_75/A vdd pfet w=20 l=2
+  ad=0 pd=0 as=0.22n ps=92u
M5858 INVX2_75/A NOR2X1_11/A OAI21X1_23/a_2_6# Gnd nfet w=20 l=2
+  ad=100p pd=50u as=0 ps=0
M5859 INVX2_75/A INVX2_74/Y OAI21X1_23/a_9_54# vdd pfet w=40 l=2
+  ad=0 pd=0 as=0.12n ps=86u
M5860 OAI21X1_23/a_9_54# NOR2X1_12/Y vdd vdd pfet w=40 l=2
+  ad=0 pd=0 as=0 ps=0
M5861 OAI21X1_23/a_2_6# INVX2_74/Y gnd Gnd nfet w=20 l=2
+  ad=0 pd=0 as=0 ps=0
M5862 gnd OR2X1_8/B OAI21X1_67/a_2_6# Gnd nfet w=20 l=2
+  ad=0 pd=0 as=0.22n ps=0.102m
M5863 vdd INVX2_149/A OAI21X1_67/Y vdd pfet w=20 l=2
+  ad=0 pd=0 as=0.22n ps=92u
M5864 OAI21X1_67/Y INVX2_149/A OAI21X1_67/a_2_6# Gnd nfet w=20 l=2
+  ad=100p pd=50u as=0 ps=0
M5865 OAI21X1_67/Y INVX2_157/Y OAI21X1_67/a_9_54# vdd pfet w=40 l=2
+  ad=0 pd=0 as=0.12n ps=86u
M5866 OAI21X1_67/a_9_54# OR2X1_8/B vdd vdd pfet w=40 l=2
+  ad=0 pd=0 as=0 ps=0
M5867 OAI21X1_67/a_2_6# INVX2_157/Y gnd Gnd nfet w=20 l=2
+  ad=0 pd=0 as=0 ps=0
M5868 gnd INVX2_27/Y OAI21X1_56/a_2_6# Gnd nfet w=20 l=2
+  ad=0 pd=0 as=0.22n ps=0.102m
M5869 vdd OAI21X1_56/C OAI21X1_56/Y vdd pfet w=20 l=2
+  ad=0 pd=0 as=0.22n ps=92u
M5870 OAI21X1_56/Y OAI21X1_56/C OAI21X1_56/a_2_6# Gnd nfet w=20 l=2
+  ad=100p pd=50u as=0 ps=0
M5871 OAI21X1_56/Y OAI22X1_4/B OAI21X1_56/a_9_54# vdd pfet w=40 l=2
+  ad=0 pd=0 as=0.12n ps=86u
M5872 OAI21X1_56/a_9_54# INVX2_27/Y vdd vdd pfet w=40 l=2
+  ad=0 pd=0 as=0 ps=0
M5873 OAI21X1_56/a_2_6# OAI22X1_4/B gnd Gnd nfet w=20 l=2
+  ad=0 pd=0 as=0 ps=0
M5874 gnd INVX2_64/Y OAI21X1_78/a_2_6# Gnd nfet w=20 l=2
+  ad=0 pd=0 as=0.22n ps=0.102m
M5875 vdd OAI21X1_79/Y OAI21X1_78/Y vdd pfet w=20 l=2
+  ad=0 pd=0 as=0.22n ps=92u
M5876 OAI21X1_78/Y OAI21X1_79/Y OAI21X1_78/a_2_6# Gnd nfet w=20 l=2
+  ad=100p pd=50u as=0 ps=0
M5877 OAI21X1_78/Y AND2X2_14/B OAI21X1_78/a_9_54# vdd pfet w=40 l=2
+  ad=0 pd=0 as=0.12n ps=86u
M5878 OAI21X1_78/a_9_54# INVX2_64/Y vdd vdd pfet w=40 l=2
+  ad=0 pd=0 as=0 ps=0
M5879 OAI21X1_78/a_2_6# AND2X2_14/B gnd Gnd nfet w=20 l=2
+  ad=0 pd=0 as=0 ps=0
M5880 gnd NOR2X1_35/B OAI21X1_89/a_2_6# Gnd nfet w=20 l=2
+  ad=0 pd=0 as=0.22n ps=0.102m
M5881 vdd NAND2X1_1/B INVX2_135/A vdd pfet w=20 l=2
+  ad=0 pd=0 as=0.22n ps=92u
M5882 INVX2_135/A NAND2X1_1/B OAI21X1_89/a_2_6# Gnd nfet w=20 l=2
+  ad=100p pd=50u as=0 ps=0
M5883 INVX2_135/A INVX2_56/A OAI21X1_89/a_9_54# vdd pfet w=40 l=2
+  ad=0 pd=0 as=0.12n ps=86u
M5884 OAI21X1_89/a_9_54# NOR2X1_35/B vdd vdd pfet w=40 l=2
+  ad=0 pd=0 as=0 ps=0
M5885 OAI21X1_89/a_2_6# INVX2_56/A gnd Gnd nfet w=20 l=2
+  ad=0 pd=0 as=0 ps=0
M5886 OR2X1_16/a_2_54# OR2X1_16/A gnd Gnd nfet w=10 l=2
+  ad=59.999996p pd=32u as=0 ps=0
M5887 OR2X1_16/Y OR2X1_16/a_2_54# vdd vdd pfet w=20 l=2
+  ad=100p pd=50u as=0 ps=0
M5888 OR2X1_16/Y OR2X1_16/a_2_54# gnd Gnd nfet w=10 l=2
+  ad=50p pd=30u as=0 ps=0
M5889 vdd OR2X1_16/B OR2X1_16/a_9_54# vdd pfet w=40 l=2
+  ad=0 pd=0 as=0.12n ps=86u
M5890 OR2X1_16/a_9_54# OR2X1_16/A OR2X1_16/a_2_54# vdd pfet w=40 l=2
+  ad=0 pd=0 as=0.2n ps=90u
M5891 gnd OR2X1_16/B OR2X1_16/a_2_54# Gnd nfet w=10 l=2
+  ad=0 pd=0 as=0 ps=0
M5892 AND2X2_15/a_2_6# AND2X2_15/A vdd vdd pfet w=20 l=2
+  ad=0.12n pd=52u as=0 ps=0
M5893 AND2X2_15/a_9_6# AND2X2_15/A AND2X2_15/a_2_6# Gnd nfet w=20 l=2
+  ad=59.999996p pd=46u as=100p ps=50u
M5894 AND2X2_15/Y AND2X2_15/a_2_6# gnd Gnd nfet w=20 l=2
+  ad=100p pd=50u as=0 ps=0
M5895 AND2X2_15/Y AND2X2_15/a_2_6# vdd vdd pfet w=40 l=2
+  ad=0.2n pd=90u as=0 ps=0
M5896 vdd OR2X1_2/Y AND2X2_15/a_2_6# vdd pfet w=20 l=2
+  ad=0 pd=0 as=0 ps=0
M5897 gnd OR2X1_2/Y AND2X2_15/a_9_6# Gnd nfet w=20 l=2
+  ad=0 pd=0 as=0 ps=0
M5898 vdd player_coord_x[3] HAX1_3/a_2_74# vdd pfet w=20 l=2
+  ad=0 pd=0 as=0.2n ps=100u
M5899 HAX1_3/a_41_74# HAX1_3/a_2_74# vdd vdd pfet w=20 l=2
+  ad=0.22n pd=92u as=0 ps=0
M5900 HAX1_3/a_9_6# player_coord_x[3] gnd Gnd nfet w=20 l=2
+  ad=59.999996p pd=46u as=0 ps=0
M5901 HAX1_3/a_41_74# HAX1_3/B HAX1_3/a_38_6# Gnd nfet w=20 l=2
+  ad=0.12n pd=52u as=0.216n ps=0.102m
M5902 vdd player_coord_x[3] HAX1_3/a_49_54# vdd pfet w=40 l=2
+  ad=0 pd=0 as=0.12n ps=86u
M5903 vdd HAX1_3/a_2_74# OR2X1_4/B vdd pfet w=20 l=2
+  ad=0 pd=0 as=100p ps=50u
M5904 HAX1_3/a_38_6# HAX1_3/a_2_74# gnd Gnd nfet w=20 l=2
+  ad=0 pd=0 as=0 ps=0
M5905 HAX1_3/YS HAX1_3/a_41_74# vdd vdd pfet w=20 l=2
+  ad=100p pd=50u as=0 ps=0
M5906 HAX1_3/a_38_6# player_coord_x[3] HAX1_3/a_41_74# Gnd nfet w=20 l=2
+  ad=0 pd=0 as=0 ps=0
M5907 HAX1_3/YS HAX1_3/a_41_74# gnd Gnd nfet w=10 l=2
+  ad=50p pd=30u as=0 ps=0
M5908 HAX1_3/a_2_74# HAX1_3/B vdd vdd pfet w=20 l=2
+  ad=0 pd=0 as=0 ps=0
M5909 HAX1_3/a_2_74# HAX1_3/B HAX1_3/a_9_6# Gnd nfet w=20 l=2
+  ad=100p pd=50u as=0 ps=0
M5910 HAX1_3/a_49_54# HAX1_3/B HAX1_3/a_41_74# vdd pfet w=40 l=2
+  ad=0 pd=0 as=0 ps=0
M5911 gnd HAX1_3/a_2_74# OR2X1_4/B Gnd nfet w=10 l=2
+  ad=0 pd=0 as=50p ps=30u
M5912 INVX2_123/A OR2X1_19/Y vdd vdd pfet w=20 l=2
+  ad=0.22n pd=0.102m as=0 ps=0
M5913 NAND3X1_48/a_9_6# OR2X1_19/Y gnd Gnd nfet w=30 l=2
+  ad=90p pd=66u as=0 ps=0
M5914 INVX2_123/A player_display vdd vdd pfet w=20 l=2
+  ad=0 pd=0 as=0 ps=0
M5915 INVX2_123/A player_display NAND3X1_48/a_14_6# Gnd nfet w=30 l=2
+  ad=0.15n pd=70u as=90p ps=66u
M5916 vdd NAND3X1_48/B INVX2_123/A vdd pfet w=20 l=2
+  ad=0 pd=0 as=0 ps=0
M5917 NAND3X1_48/a_14_6# NAND3X1_48/B NAND3X1_48/a_9_6# Gnd nfet w=30 l=2
+  ad=0 pd=0 as=0 ps=0
M5918 OAI21X1_92/A OAI21X1_31/Y vdd vdd pfet w=20 l=2
+  ad=0.22n pd=0.102m as=0 ps=0
M5919 NAND3X1_37/a_9_6# OAI21X1_31/Y gnd Gnd nfet w=30 l=2
+  ad=90p pd=66u as=0 ps=0
M5920 OAI21X1_92/A AND2X2_16/Y vdd vdd pfet w=20 l=2
+  ad=0 pd=0 as=0 ps=0
M5921 OAI21X1_92/A AND2X2_16/Y NAND3X1_37/a_14_6# Gnd nfet w=30 l=2
+  ad=0.15n pd=70u as=90p ps=66u
M5922 vdd INVX2_132/Y OAI21X1_92/A vdd pfet w=20 l=2
+  ad=0 pd=0 as=0 ps=0
M5923 NAND3X1_37/a_14_6# INVX2_132/Y NAND3X1_37/a_9_6# Gnd nfet w=30 l=2
+  ad=0 pd=0 as=0 ps=0
M5924 NOR2X1_23/B player_bullet_coord_y[1] vdd vdd pfet w=20 l=2
+  ad=0.22n pd=0.102m as=0 ps=0
M5925 NAND3X1_15/a_9_6# player_bullet_coord_y[1] gnd Gnd nfet w=30 l=2
+  ad=90p pd=66u as=0 ps=0
M5926 NOR2X1_23/B player_bullet_coord_y[2] vdd vdd pfet w=20 l=2
+  ad=0 pd=0 as=0 ps=0
M5927 NOR2X1_23/B player_bullet_coord_y[2] NAND3X1_15/a_14_6# Gnd nfet w=30 l=2
+  ad=0.15n pd=70u as=90p ps=66u
M5928 vdd player_bullet_coord_y[0] NOR2X1_23/B vdd pfet w=20 l=2
+  ad=0 pd=0 as=0 ps=0
M5929 NAND3X1_15/a_14_6# player_bullet_coord_y[0] NAND3X1_15/a_9_6# Gnd nfet w=30 l=2
+  ad=0 pd=0 as=0 ps=0
M5930 OAI21X1_75/C OAI22X1_5/B vdd vdd pfet w=20 l=2
+  ad=0.22n pd=0.102m as=0 ps=0
M5931 NAND3X1_26/a_9_6# OAI22X1_5/B gnd Gnd nfet w=30 l=2
+  ad=90p pd=66u as=0 ps=0
M5932 OAI21X1_75/C INVX2_56/A vdd vdd pfet w=20 l=2
+  ad=0 pd=0 as=0 ps=0
M5933 OAI21X1_75/C INVX2_56/A NAND3X1_26/a_14_6# Gnd nfet w=30 l=2
+  ad=0.15n pd=70u as=90p ps=66u
M5934 vdd NAND2X1_1/B OAI21X1_75/C vdd pfet w=20 l=2
+  ad=0 pd=0 as=0 ps=0
M5935 NAND3X1_26/a_14_6# NAND2X1_1/B NAND3X1_26/a_9_6# Gnd nfet w=30 l=2
+  ad=0 pd=0 as=0 ps=0
M5936 NOR2X1_37/Y player_bullet_coord_y[3] gnd Gnd nfet w=10 l=2
+  ad=59.999996p pd=32u as=0 ps=0
M5937 NOR2X1_37/Y XOR2X1_9/Y NOR2X1_37/a_9_54# vdd pfet w=40 l=2
+  ad=0.2n pd=90u as=0.12n ps=86u
M5938 NOR2X1_37/a_9_54# player_bullet_coord_y[3] vdd vdd pfet w=40 l=2
+  ad=0 pd=0 as=0 ps=0
M5939 gnd XOR2X1_9/Y NOR2X1_37/Y Gnd nfet w=10 l=2
+  ad=0 pd=0 as=0 ps=0
M5940 NOR2X1_16/B invader_bullet_coord_y[1] gnd Gnd nfet w=10 l=2
+  ad=59.999996p pd=32u as=0 ps=0
M5941 NOR2X1_16/B OR2X1_6/Y NOR2X1_15/a_9_54# vdd pfet w=40 l=2
+  ad=0.2n pd=90u as=0.12n ps=86u
M5942 NOR2X1_15/a_9_54# invader_bullet_coord_y[1] vdd vdd pfet w=40 l=2
+  ad=0 pd=0 as=0 ps=0
M5943 gnd OR2X1_6/Y NOR2X1_16/B Gnd nfet w=10 l=2
+  ad=0 pd=0 as=0 ps=0
M5944 NOR2X1_26/Y AND2X2_0/A gnd Gnd nfet w=10 l=2
+  ad=59.999996p pd=32u as=0 ps=0
M5945 NOR2X1_26/Y OR2X1_15/A NOR2X1_26/a_9_54# vdd pfet w=40 l=2
+  ad=0.2n pd=90u as=0.12n ps=86u
M5946 NOR2X1_26/a_9_54# AND2X2_0/A vdd vdd pfet w=40 l=2
+  ad=0 pd=0 as=0 ps=0
M5947 gnd OR2X1_15/A NOR2X1_26/Y Gnd nfet w=10 l=2
+  ad=0 pd=0 as=0 ps=0
M5948 NOR2X1_48/Y NOR2X1_48/A gnd Gnd nfet w=10 l=2
+  ad=59.999996p pd=32u as=0 ps=0
M5949 NOR2X1_48/Y INVX2_95/Y NOR2X1_48/a_9_54# vdd pfet w=40 l=2
+  ad=0.2n pd=90u as=0.12n ps=86u
M5950 NOR2X1_48/a_9_54# NOR2X1_48/A vdd vdd pfet w=40 l=2
+  ad=0 pd=0 as=0 ps=0
M5951 gnd INVX2_95/Y NOR2X1_48/Y Gnd nfet w=10 l=2
+  ad=0 pd=0 as=0 ps=0
M5952 NOR2X1_59/Y NOR2X1_59/A gnd Gnd nfet w=10 l=2
+  ad=59.999996p pd=32u as=0 ps=0
M5953 NOR2X1_59/Y NOR2X1_60/B NOR2X1_59/a_9_54# vdd pfet w=40 l=2
+  ad=0.2n pd=90u as=0.12n ps=86u
M5954 NOR2X1_59/a_9_54# NOR2X1_59/A vdd vdd pfet w=40 l=2
+  ad=0 pd=0 as=0 ps=0
M5955 gnd NOR2X1_60/B NOR2X1_59/Y Gnd nfet w=10 l=2
+  ad=0 pd=0 as=0 ps=0
M5956 INVX2_112/A NAND2X1_70/A vdd vdd pfet w=20 l=2
+  ad=0.12n pd=52u as=0 ps=0
M5957 NAND2X1_70/a_9_6# NAND2X1_70/A gnd Gnd nfet w=20 l=2
+  ad=59.999996p pd=46u as=0 ps=0
M5958 vdd invader_1_display INVX2_112/A vdd pfet w=20 l=2
+  ad=0 pd=0 as=0 ps=0
M5959 INVX2_112/A invader_1_display NAND2X1_70/a_9_6# Gnd nfet w=20 l=2
+  ad=100p pd=50u as=0 ps=0
M5960 LATCH_2/CLK INVX2_124/A vdd vdd pfet w=20 l=2
+  ad=0.12n pd=52u as=0 ps=0
M5961 NAND2X1_81/a_9_6# INVX2_124/A gnd Gnd nfet w=20 l=2
+  ad=59.999996p pd=46u as=0 ps=0
M5962 vdd INVX2_151/A LATCH_2/CLK vdd pfet w=20 l=2
+  ad=0 pd=0 as=0 ps=0
M5963 LATCH_2/CLK INVX2_151/A NAND2X1_81/a_9_6# Gnd nfet w=20 l=2
+  ad=100p pd=50u as=0 ps=0
M5964 INVX2_72/Y HAX1_8/YS gnd Gnd nfet w=20 l=2
+  ad=100p pd=50u as=0 ps=0
M5965 INVX2_72/Y HAX1_8/YS vdd vdd pfet w=40 l=2
+  ad=0.2n pd=90u as=0 ps=0
M5966 INVX2_50/Y INVX2_50/A gnd Gnd nfet w=20 l=2
+  ad=100p pd=50u as=0 ps=0
M5967 INVX2_50/Y INVX2_50/A vdd vdd pfet w=40 l=2
+  ad=0.2n pd=90u as=0 ps=0
M5968 INVX2_61/Y INVX2_61/A gnd Gnd nfet w=20 l=2
+  ad=100p pd=50u as=0 ps=0
M5969 INVX2_61/Y INVX2_61/A vdd vdd pfet w=40 l=2
+  ad=0.2n pd=90u as=0 ps=0
M5970 INVX2_83/Y INVX2_83/A gnd Gnd nfet w=20 l=2
+  ad=100p pd=50u as=0 ps=0
M5971 INVX2_83/Y INVX2_83/A vdd vdd pfet w=40 l=2
+  ad=0.2n pd=90u as=0 ps=0
M5972 INVX2_94/Y XOR2X1_4/Y gnd Gnd nfet w=20 l=2
+  ad=100p pd=50u as=0 ps=0
M5973 INVX2_94/Y XOR2X1_4/Y vdd vdd pfet w=40 l=2
+  ad=0.2n pd=90u as=0 ps=0
M5974 gnd invader_bullet_coord_x[3] OAI21X1_35/a_2_6# Gnd nfet w=20 l=2
+  ad=0 pd=0 as=0.22n ps=0.102m
M5975 vdd OAI21X1_35/C INVX2_122/A vdd pfet w=20 l=2
+  ad=0 pd=0 as=0.22n ps=92u
M5976 INVX2_122/A OAI21X1_35/C OAI21X1_35/a_2_6# Gnd nfet w=20 l=2
+  ad=100p pd=50u as=0 ps=0
M5977 INVX2_122/A INVX2_121/Y OAI21X1_35/a_9_54# vdd pfet w=40 l=2
+  ad=0 pd=0 as=0.12n ps=86u
M5978 OAI21X1_35/a_9_54# invader_bullet_coord_x[3] vdd vdd pfet w=40 l=2
+  ad=0 pd=0 as=0 ps=0
M5979 OAI21X1_35/a_2_6# INVX2_121/Y gnd Gnd nfet w=20 l=2
+  ad=0 pd=0 as=0 ps=0
M5980 gnd INVX2_41/Y OAI21X1_13/a_2_6# Gnd nfet w=20 l=2
+  ad=0 pd=0 as=0.22n ps=0.102m
M5981 vdd NAND3X1_3/Y INVX2_42/A vdd pfet w=20 l=2
+  ad=0 pd=0 as=0.22n ps=92u
M5982 INVX2_42/A NAND3X1_3/Y OAI21X1_13/a_2_6# Gnd nfet w=20 l=2
+  ad=100p pd=50u as=0 ps=0
M5983 INVX2_42/A INVX2_23/Y OAI21X1_13/a_9_54# vdd pfet w=40 l=2
+  ad=0 pd=0 as=0.12n ps=86u
M5984 OAI21X1_13/a_9_54# INVX2_41/Y vdd vdd pfet w=40 l=2
+  ad=0 pd=0 as=0 ps=0
M5985 OAI21X1_13/a_2_6# INVX2_23/Y gnd Gnd nfet w=20 l=2
+  ad=0 pd=0 as=0 ps=0
M5986 gnd INVX2_80/A OAI21X1_24/a_2_6# Gnd nfet w=20 l=2
+  ad=0 pd=0 as=0.22n ps=0.102m
M5987 vdd INVX2_81/Y OAI21X1_24/Y vdd pfet w=20 l=2
+  ad=0 pd=0 as=0.22n ps=92u
M5988 OAI21X1_24/Y INVX2_81/Y OAI21X1_24/a_2_6# Gnd nfet w=20 l=2
+  ad=100p pd=50u as=0 ps=0
M5989 OAI21X1_24/Y OAI21X1_25/Y OAI21X1_24/a_9_54# vdd pfet w=40 l=2
+  ad=0 pd=0 as=0.12n ps=86u
M5990 OAI21X1_24/a_9_54# INVX2_80/A vdd vdd pfet w=40 l=2
+  ad=0 pd=0 as=0 ps=0
M5991 OAI21X1_24/a_2_6# OAI21X1_25/Y gnd Gnd nfet w=20 l=2
+  ad=0 pd=0 as=0 ps=0
M5992 gnd invader_bullet_coord_y[0] OAI21X1_46/a_2_6# Gnd nfet w=20 l=2
+  ad=0 pd=0 as=0.22n ps=0.102m
M5993 vdd OAI21X1_46/C OAI21X1_46/Y vdd pfet w=20 l=2
+  ad=0 pd=0 as=0.22n ps=92u
M5994 OAI21X1_46/Y OAI21X1_46/C OAI21X1_46/a_2_6# Gnd nfet w=20 l=2
+  ad=100p pd=50u as=0 ps=0
M5995 OAI21X1_46/Y INVX2_2/Y OAI21X1_46/a_9_54# vdd pfet w=40 l=2
+  ad=0 pd=0 as=0.12n ps=86u
M5996 OAI21X1_46/a_9_54# invader_bullet_coord_y[0] vdd vdd pfet w=40 l=2
+  ad=0 pd=0 as=0 ps=0
M5997 OAI21X1_46/a_2_6# INVX2_2/Y gnd Gnd nfet w=20 l=2
+  ad=0 pd=0 as=0 ps=0
M5998 gnd INVX2_32/Y OAI21X1_68/a_2_6# Gnd nfet w=20 l=2
+  ad=0 pd=0 as=0.22n ps=0.102m
M5999 vdd NOR2X1_31/Y INVX2_149/A vdd pfet w=20 l=2
+  ad=0 pd=0 as=0.22n ps=92u
M6000 INVX2_149/A NOR2X1_31/Y OAI21X1_68/a_2_6# Gnd nfet w=20 l=2
+  ad=100p pd=50u as=0 ps=0
M6001 INVX2_149/A OAI21X1_68/B OAI21X1_68/a_9_54# vdd pfet w=40 l=2
+  ad=0 pd=0 as=0.12n ps=86u
M6002 OAI21X1_68/a_9_54# INVX2_32/Y vdd vdd pfet w=40 l=2
+  ad=0 pd=0 as=0 ps=0
M6003 OAI21X1_68/a_2_6# OAI21X1_68/B gnd Gnd nfet w=20 l=2
+  ad=0 pd=0 as=0 ps=0
M6004 gnd OAI22X1_4/B OAI21X1_57/a_2_6# Gnd nfet w=20 l=2
+  ad=0 pd=0 as=0.22n ps=0.102m
M6005 vdd OAI21X1_57/C OAI21X1_57/Y vdd pfet w=20 l=2
+  ad=0 pd=0 as=0.22n ps=92u
M6006 OAI21X1_57/Y OAI21X1_57/C OAI21X1_57/a_2_6# Gnd nfet w=20 l=2
+  ad=100p pd=50u as=0 ps=0
M6007 OAI21X1_57/Y INVX2_28/Y OAI21X1_57/a_9_54# vdd pfet w=40 l=2
+  ad=0 pd=0 as=0.12n ps=86u
M6008 OAI21X1_57/a_9_54# OAI22X1_4/B vdd vdd pfet w=40 l=2
+  ad=0 pd=0 as=0 ps=0
M6009 OAI21X1_57/a_2_6# INVX2_28/Y gnd Gnd nfet w=20 l=2
+  ad=0 pd=0 as=0 ps=0
M6010 gnd OR2X1_9/A OAI21X1_79/a_2_6# Gnd nfet w=20 l=2
+  ad=0 pd=0 as=0.22n ps=0.102m
M6011 vdd AND2X2_14/B OAI21X1_79/Y vdd pfet w=20 l=2
+  ad=0 pd=0 as=0.22n ps=92u
M6012 OAI21X1_79/Y AND2X2_14/B OAI21X1_79/a_2_6# Gnd nfet w=20 l=2
+  ad=100p pd=50u as=0 ps=0
M6013 OAI21X1_79/Y INVX2_155/Y OAI21X1_79/a_9_54# vdd pfet w=40 l=2
+  ad=0 pd=0 as=0.12n ps=86u
M6014 OAI21X1_79/a_9_54# OR2X1_9/A vdd vdd pfet w=40 l=2
+  ad=0 pd=0 as=0 ps=0
M6015 OAI21X1_79/a_2_6# INVX2_155/Y gnd Gnd nfet w=20 l=2
+  ad=0 pd=0 as=0 ps=0
M6016 OR2X1_17/a_2_54# OR2X1_17/A gnd Gnd nfet w=10 l=2
+  ad=59.999996p pd=32u as=0 ps=0
M6017 OR2X1_17/Y OR2X1_17/a_2_54# vdd vdd pfet w=20 l=2
+  ad=100p pd=50u as=0 ps=0
M6018 OR2X1_17/Y OR2X1_17/a_2_54# gnd Gnd nfet w=10 l=2
+  ad=50p pd=30u as=0 ps=0
M6019 vdd invader_bullet_coord_x[1] OR2X1_17/a_9_54# vdd pfet w=40 l=2
+  ad=0 pd=0 as=0.12n ps=86u
M6020 OR2X1_17/a_9_54# OR2X1_17/A OR2X1_17/a_2_54# vdd pfet w=40 l=2
+  ad=0 pd=0 as=0.2n ps=90u
M6021 gnd invader_bullet_coord_x[1] OR2X1_17/a_2_54# Gnd nfet w=10 l=2
+  ad=0 pd=0 as=0 ps=0
M6022 AND2X2_16/a_2_6# shield_hp[1] vdd vdd pfet w=20 l=2
+  ad=0.12n pd=52u as=0 ps=0
M6023 AND2X2_16/a_9_6# shield_hp[1] AND2X2_16/a_2_6# Gnd nfet w=20 l=2
+  ad=59.999996p pd=46u as=100p ps=50u
M6024 AND2X2_16/Y AND2X2_16/a_2_6# gnd Gnd nfet w=20 l=2
+  ad=100p pd=50u as=0 ps=0
M6025 AND2X2_16/Y AND2X2_16/a_2_6# vdd vdd pfet w=40 l=2
+  ad=0.2n pd=90u as=0 ps=0
M6026 vdd AND2X2_16/B AND2X2_16/a_2_6# vdd pfet w=20 l=2
+  ad=0 pd=0 as=0 ps=0
M6027 gnd AND2X2_16/B AND2X2_16/a_9_6# Gnd nfet w=20 l=2
+  ad=0 pd=0 as=0 ps=0
M6028 gnd invader_bullet_coord_y[1] XNOR2X1_0/a_2_6# Gnd nfet w=20 l=2
+  ad=0 pd=0 as=100p ps=50u
M6029 XNOR2X1_0/Y invader_bullet_coord_y[1] XNOR2X1_0/a_18_6# Gnd nfet w=20 l=2
+  ad=0.2n pd=60u as=59.999996p ps=46u
M6030 XNOR2X1_0/a_12_41# invader_bullet_coord_y[0] gnd Gnd nfet w=20 l=2
+  ad=100p pd=50u as=0 ps=0
M6031 XNOR2X1_0/a_18_54# XNOR2X1_0/a_12_41# vdd vdd pfet w=40 l=2
+  ad=0.12n pd=86u as=0 ps=0
M6032 XNOR2X1_0/a_35_6# XNOR2X1_0/a_2_6# XNOR2X1_0/Y Gnd nfet w=20 l=2
+  ad=59.999996p pd=46u as=0 ps=0
M6033 XNOR2X1_0/a_18_6# XNOR2X1_0/a_12_41# gnd Gnd nfet w=20 l=2
+  ad=0 pd=0 as=0 ps=0
M6034 vdd invader_bullet_coord_y[1] XNOR2X1_0/a_2_6# vdd pfet w=40 l=2
+  ad=0 pd=0 as=0.2n ps=90u
M6035 vdd invader_bullet_coord_y[0] XNOR2X1_0/a_35_54# vdd pfet w=40 l=2
+  ad=0 pd=0 as=0.12n ps=86u
M6036 XNOR2X1_0/Y XNOR2X1_0/a_2_6# XNOR2X1_0/a_18_54# vdd pfet w=40 l=2
+  ad=0.4n pd=100u as=0 ps=0
M6037 XNOR2X1_0/a_35_54# invader_bullet_coord_y[1] XNOR2X1_0/Y vdd pfet w=40 l=2
+  ad=0 pd=0 as=0 ps=0
M6038 XNOR2X1_0/a_12_41# invader_bullet_coord_y[0] vdd vdd pfet w=40 l=2
+  ad=0.2n pd=90u as=0 ps=0
M6039 gnd invader_bullet_coord_y[0] XNOR2X1_0/a_35_6# Gnd nfet w=20 l=2
+  ad=0 pd=0 as=0 ps=0
M6040 DFFNEGX1_90/a_76_6# BUFX2_2/Y DFFNEGX1_90/a_66_6# Gnd nfet w=10 l=2
+  ad=29.999998p pd=26u as=80p ps=36u
M6041 gnd BUFX2_2/Y DFFNEGX1_90/a_2_6# Gnd nfet w=20 l=2
+  ad=0 pd=0 as=100p ps=50u
M6042 DFFNEGX1_90/a_66_6# DFFNEGX1_90/a_2_6# DFFNEGX1_90/a_61_6# Gnd nfet w=10 l=2
+  ad=0 pd=0 as=29.999998p ps=26u
M6043 AOI22X1_48/C DFFNEGX1_90/a_66_6# gnd Gnd nfet w=20 l=2
+  ad=100p pd=50u as=0 ps=0
M6044 DFFNEGX1_90/a_23_6# BUFX2_2/Y DFFNEGX1_90/a_17_6# Gnd nfet w=10 l=2
+  ad=59.999996p pd=32u as=40p ps=28u
M6045 DFFNEGX1_90/a_23_6# DFFNEGX1_90/a_2_6# DFFNEGX1_90/a_17_74# vdd pfet w=20 l=2
+  ad=0.12n pd=52u as=80p ps=48u
M6046 gnd DFFNEGX1_90/a_34_4# DFFNEGX1_90/a_31_6# Gnd nfet w=10 l=2
+  ad=0 pd=0 as=29.999998p ps=26u
M6047 vdd DFFNEGX1_90/a_34_4# DFFNEGX1_90/a_31_74# vdd pfet w=20 l=2
+  ad=0 pd=0 as=80p ps=48u
M6048 DFFNEGX1_90/a_61_74# DFFNEGX1_90/a_34_4# vdd vdd pfet w=20 l=2
+  ad=59.999996p pd=46u as=0 ps=0
M6049 DFFNEGX1_90/a_34_4# DFFNEGX1_90/a_23_6# vdd vdd pfet w=20 l=2
+  ad=100p pd=50u as=0 ps=0
M6050 DFFNEGX1_90/a_34_4# DFFNEGX1_90/a_23_6# gnd Gnd nfet w=10 l=2
+  ad=50p pd=30u as=0 ps=0
M6051 vdd AOI22X1_48/C DFFNEGX1_90/a_76_84# vdd pfet w=10 l=2
+  ad=0 pd=0 as=29.999998p ps=26u
M6052 gnd AOI22X1_48/C DFFNEGX1_90/a_76_6# Gnd nfet w=10 l=2
+  ad=0 pd=0 as=0 ps=0
M6053 DFFNEGX1_90/a_61_6# DFFNEGX1_90/a_34_4# gnd Gnd nfet w=10 l=2
+  ad=0 pd=0 as=0 ps=0
M6054 DFFNEGX1_90/a_76_84# DFFNEGX1_90/a_2_6# DFFNEGX1_90/a_66_6# vdd pfet w=10 l=2
+  ad=0 pd=0 as=0.15n ps=56u
M6055 AOI22X1_48/C DFFNEGX1_90/a_66_6# vdd vdd pfet w=40 l=2
+  ad=0.2n pd=90u as=0 ps=0
M6056 vdd BUFX2_2/Y DFFNEGX1_90/a_2_6# vdd pfet w=40 l=2
+  ad=0 pd=0 as=0.2n ps=90u
M6057 DFFNEGX1_90/a_31_6# DFFNEGX1_90/a_2_6# DFFNEGX1_90/a_23_6# Gnd nfet w=10 l=2
+  ad=0 pd=0 as=0 ps=0
M6058 DFFNEGX1_90/a_66_6# BUFX2_2/Y DFFNEGX1_90/a_61_74# vdd pfet w=20 l=2
+  ad=0 pd=0 as=0 ps=0
M6059 DFFNEGX1_90/a_17_74# INVX2_170/Y vdd vdd pfet w=20 l=2
+  ad=0 pd=0 as=0 ps=0
M6060 DFFNEGX1_90/a_31_74# BUFX2_2/Y DFFNEGX1_90/a_23_6# vdd pfet w=20 l=2
+  ad=0 pd=0 as=0 ps=0
M6061 DFFNEGX1_90/a_17_6# INVX2_170/Y gnd Gnd nfet w=10 l=2
+  ad=0 pd=0 as=0 ps=0
M6062 vdd player_coord_x[2] HAX1_4/a_2_74# vdd pfet w=20 l=2
+  ad=0 pd=0 as=0.2n ps=100u
M6063 HAX1_4/a_41_74# HAX1_4/a_2_74# vdd vdd pfet w=20 l=2
+  ad=0.22n pd=92u as=0 ps=0
M6064 HAX1_4/a_9_6# player_coord_x[2] gnd Gnd nfet w=20 l=2
+  ad=59.999996p pd=46u as=0 ps=0
M6065 HAX1_4/a_41_74# HAX1_4/B HAX1_4/a_38_6# Gnd nfet w=20 l=2
+  ad=0.12n pd=52u as=0.216n ps=0.102m
M6066 vdd player_coord_x[2] HAX1_4/a_49_54# vdd pfet w=40 l=2
+  ad=0 pd=0 as=0.12n ps=86u
M6067 vdd HAX1_4/a_2_74# HAX1_3/B vdd pfet w=20 l=2
+  ad=0 pd=0 as=100p ps=50u
M6068 HAX1_4/a_38_6# HAX1_4/a_2_74# gnd Gnd nfet w=20 l=2
+  ad=0 pd=0 as=0 ps=0
M6069 HAX1_4/YS HAX1_4/a_41_74# vdd vdd pfet w=20 l=2
+  ad=100p pd=50u as=0 ps=0
M6070 HAX1_4/a_38_6# player_coord_x[2] HAX1_4/a_41_74# Gnd nfet w=20 l=2
+  ad=0 pd=0 as=0 ps=0
M6071 HAX1_4/YS HAX1_4/a_41_74# gnd Gnd nfet w=10 l=2
+  ad=50p pd=30u as=0 ps=0
M6072 HAX1_4/a_2_74# HAX1_4/B vdd vdd pfet w=20 l=2
+  ad=0 pd=0 as=0 ps=0
M6073 HAX1_4/a_2_74# HAX1_4/B HAX1_4/a_9_6# Gnd nfet w=20 l=2
+  ad=100p pd=50u as=0 ps=0
M6074 HAX1_4/a_49_54# HAX1_4/B HAX1_4/a_41_74# vdd pfet w=40 l=2
+  ad=0 pd=0 as=0 ps=0
M6075 gnd HAX1_4/a_2_74# HAX1_3/B Gnd nfet w=10 l=2
+  ad=0 pd=0 as=50p ps=30u
M6076 AND2X2_0/a_2_6# AND2X2_0/A vdd vdd pfet w=20 l=2
+  ad=0.12n pd=52u as=0 ps=0
M6077 AND2X2_0/a_9_6# AND2X2_0/A AND2X2_0/a_2_6# Gnd nfet w=20 l=2
+  ad=59.999996p pd=46u as=100p ps=50u
M6078 AND2X2_0/Y AND2X2_0/a_2_6# gnd Gnd nfet w=20 l=2
+  ad=100p pd=50u as=0 ps=0
M6079 AND2X2_0/Y AND2X2_0/a_2_6# vdd vdd pfet w=40 l=2
+  ad=0.2n pd=90u as=0 ps=0
M6080 vdd AND2X2_0/B AND2X2_0/a_2_6# vdd pfet w=20 l=2
+  ad=0 pd=0 as=0 ps=0
M6081 gnd AND2X2_0/B AND2X2_0/a_9_6# Gnd nfet w=20 l=2
+  ad=0 pd=0 as=0 ps=0
M6082 OAI21X1_96/C OAI21X1_97/A vdd vdd pfet w=20 l=2
+  ad=0.22n pd=0.102m as=0 ps=0
M6083 NAND3X1_38/a_9_6# OAI21X1_97/A gnd Gnd nfet w=30 l=2
+  ad=90p pd=66u as=0 ps=0
M6084 OAI21X1_96/C INVX2_88/A vdd vdd pfet w=20 l=2
+  ad=0 pd=0 as=0 ps=0
M6085 OAI21X1_96/C INVX2_88/A NAND3X1_38/a_14_6# Gnd nfet w=30 l=2
+  ad=0.15n pd=70u as=90p ps=66u
M6086 vdd NAND2X1_1/B OAI21X1_96/C vdd pfet w=20 l=2
+  ad=0 pd=0 as=0 ps=0
M6087 NAND3X1_38/a_14_6# NAND2X1_1/B NAND3X1_38/a_9_6# Gnd nfet w=30 l=2
+  ad=0 pd=0 as=0 ps=0
M6088 OAI21X1_76/C OAI22X1_5/B vdd vdd pfet w=20 l=2
+  ad=0.22n pd=0.102m as=0 ps=0
M6089 NAND3X1_27/a_9_6# OAI22X1_5/B gnd Gnd nfet w=30 l=2
+  ad=90p pd=66u as=0 ps=0
M6090 OAI21X1_76/C NOR2X1_35/B vdd vdd pfet w=20 l=2
+  ad=0 pd=0 as=0 ps=0
M6091 OAI21X1_76/C NOR2X1_35/B NAND3X1_27/a_14_6# Gnd nfet w=30 l=2
+  ad=0.15n pd=70u as=90p ps=66u
M6092 vdd NAND2X1_1/B OAI21X1_76/C vdd pfet w=20 l=2
+  ad=0 pd=0 as=0 ps=0
M6093 NAND3X1_27/a_14_6# NAND2X1_1/B NAND3X1_27/a_9_6# Gnd nfet w=30 l=2
+  ad=0 pd=0 as=0 ps=0
M6094 OAI21X1_56/C OAI22X1_4/B vdd vdd pfet w=20 l=2
+  ad=0.22n pd=0.102m as=0 ps=0
M6095 NAND3X1_16/a_9_6# OAI22X1_4/B gnd Gnd nfet w=30 l=2
+  ad=90p pd=66u as=0 ps=0
M6096 OAI21X1_56/C INVX2_26/A vdd vdd pfet w=20 l=2
+  ad=0 pd=0 as=0 ps=0
M6097 OAI21X1_56/C INVX2_26/A NAND3X1_16/a_14_6# Gnd nfet w=30 l=2
+  ad=0.15n pd=70u as=90p ps=66u
M6098 vdd NAND2X1_1/B OAI21X1_56/C vdd pfet w=20 l=2
+  ad=0 pd=0 as=0 ps=0
M6099 NAND3X1_16/a_14_6# NAND2X1_1/B NAND3X1_16/a_9_6# Gnd nfet w=30 l=2
+  ad=0 pd=0 as=0 ps=0
M6100 NOR2X1_27/Y OR2X1_15/A gnd Gnd nfet w=10 l=2
+  ad=59.999996p pd=32u as=0 ps=0
M6101 NOR2X1_27/Y NOR2X1_27/B NOR2X1_27/a_9_54# vdd pfet w=40 l=2
+  ad=0.2n pd=90u as=0.12n ps=86u
M6102 NOR2X1_27/a_9_54# OR2X1_15/A vdd vdd pfet w=40 l=2
+  ad=0 pd=0 as=0 ps=0
M6103 gnd NOR2X1_27/B NOR2X1_27/Y Gnd nfet w=10 l=2
+  ad=0 pd=0 as=0 ps=0
M6104 OR2X1_16/A NOR2X1_4/Y gnd Gnd nfet w=10 l=2
+  ad=59.999996p pd=32u as=0 ps=0
M6105 OR2X1_16/A NOR2X1_16/B NOR2X1_16/a_9_54# vdd pfet w=40 l=2
+  ad=0.2n pd=90u as=0.12n ps=86u
M6106 NOR2X1_16/a_9_54# NOR2X1_4/Y vdd vdd pfet w=40 l=2
+  ad=0 pd=0 as=0 ps=0
M6107 gnd NOR2X1_16/B OR2X1_16/A Gnd nfet w=10 l=2
+  ad=0 pd=0 as=0 ps=0
M6108 NOR2X1_49/Y OR2X1_15/A gnd Gnd nfet w=10 l=2
+  ad=59.999996p pd=32u as=0 ps=0
M6109 NOR2X1_49/Y NOR2X1_49/B NOR2X1_49/a_9_54# vdd pfet w=40 l=2
+  ad=0.2n pd=90u as=0.12n ps=86u
M6110 NOR2X1_49/a_9_54# OR2X1_15/A vdd vdd pfet w=40 l=2
+  ad=0 pd=0 as=0 ps=0
M6111 gnd NOR2X1_49/B NOR2X1_49/Y Gnd nfet w=10 l=2
+  ad=0 pd=0 as=0 ps=0
M6112 NOR2X1_38/Y INVX2_89/A gnd Gnd nfet w=10 l=2
+  ad=59.999996p pd=32u as=0 ps=0
M6113 NOR2X1_38/Y INVX2_88/Y NOR2X1_38/a_9_54# vdd pfet w=40 l=2
+  ad=0.2n pd=90u as=0.12n ps=86u
M6114 NOR2X1_38/a_9_54# INVX2_89/A vdd vdd pfet w=40 l=2
+  ad=0 pd=0 as=0 ps=0
M6115 gnd INVX2_88/Y NOR2X1_38/Y Gnd nfet w=10 l=2
+  ad=0 pd=0 as=0 ps=0
M6116 NAND2X1_60/Y invader_bullet_coord_x[1] vdd vdd pfet w=20 l=2
+  ad=0.12n pd=52u as=0 ps=0
M6117 NAND2X1_60/a_9_6# invader_bullet_coord_x[1] gnd Gnd nfet w=20 l=2
+  ad=59.999996p pd=46u as=0 ps=0
M6118 vdd OR2X1_17/A NAND2X1_60/Y vdd pfet w=20 l=2
+  ad=0 pd=0 as=0 ps=0
M6119 NAND2X1_60/Y OR2X1_17/A NAND2X1_60/a_9_6# Gnd nfet w=20 l=2
+  ad=100p pd=50u as=0 ps=0
M6120 INVX2_151/A INVX2_124/A vdd vdd pfet w=20 l=2
+  ad=0.12n pd=52u as=0 ps=0
M6121 NAND2X1_82/a_9_6# INVX2_124/A gnd Gnd nfet w=20 l=2
+  ad=59.999996p pd=46u as=0 ps=0
M6122 vdd INVX2_150/Y INVX2_151/A vdd pfet w=20 l=2
+  ad=0 pd=0 as=0 ps=0
M6123 INVX2_151/A INVX2_150/Y NAND2X1_82/a_9_6# Gnd nfet w=20 l=2
+  ad=100p pd=50u as=0 ps=0
M6124 INVX2_109/A NAND2X1_71/A vdd vdd pfet w=20 l=2
+  ad=0.12n pd=52u as=0 ps=0
M6125 NAND2X1_71/a_9_6# NAND2X1_71/A gnd Gnd nfet w=20 l=2
+  ad=59.999996p pd=46u as=0 ps=0
M6126 vdd invader_2_display INVX2_109/A vdd pfet w=20 l=2
+  ad=0 pd=0 as=0 ps=0
M6127 INVX2_109/A invader_2_display NAND2X1_71/a_9_6# Gnd nfet w=20 l=2
+  ad=100p pd=50u as=0 ps=0
M6128 INVX2_40/Y INVX2_40/A gnd Gnd nfet w=20 l=2
+  ad=100p pd=50u as=0 ps=0
M6129 INVX2_40/Y INVX2_40/A vdd vdd pfet w=40 l=2
+  ad=0.2n pd=90u as=0 ps=0
M6130 INVX2_73/Y INVX2_73/A gnd Gnd nfet w=20 l=2
+  ad=100p pd=50u as=0 ps=0
M6131 INVX2_73/Y INVX2_73/A vdd vdd pfet w=40 l=2
+  ad=0.2n pd=90u as=0 ps=0
M6132 INVX2_51/Y INVX2_51/A gnd Gnd nfet w=20 l=2
+  ad=100p pd=50u as=0 ps=0
M6133 INVX2_51/Y INVX2_51/A vdd vdd pfet w=40 l=2
+  ad=0.2n pd=90u as=0 ps=0
M6134 INVX2_62/Y INVX2_62/A gnd Gnd nfet w=20 l=2
+  ad=100p pd=50u as=0 ps=0
M6135 INVX2_62/Y INVX2_62/A vdd vdd pfet w=40 l=2
+  ad=0.2n pd=90u as=0 ps=0
M6136 INVX2_95/Y INVX2_95/A gnd Gnd nfet w=20 l=2
+  ad=100p pd=50u as=0 ps=0
M6137 INVX2_95/Y INVX2_95/A vdd vdd pfet w=40 l=2
+  ad=0.2n pd=90u as=0 ps=0
M6138 INVX2_84/Y INVX2_84/A gnd Gnd nfet w=20 l=2
+  ad=100p pd=50u as=0 ps=0
M6139 INVX2_84/Y INVX2_84/A vdd vdd pfet w=40 l=2
+  ad=0.2n pd=90u as=0 ps=0
M6140 gnd INVX2_73/Y OAI21X1_25/a_2_6# Gnd nfet w=20 l=2
+  ad=0 pd=0 as=0.22n ps=0.102m
M6141 vdd OAI22X1_3/Y OAI21X1_25/Y vdd pfet w=20 l=2
+  ad=0 pd=0 as=0.22n ps=92u
M6142 OAI21X1_25/Y OAI22X1_3/Y OAI21X1_25/a_2_6# Gnd nfet w=20 l=2
+  ad=100p pd=50u as=0 ps=0
M6143 OAI21X1_25/Y INVX2_22/Y OAI21X1_25/a_9_54# vdd pfet w=40 l=2
+  ad=0 pd=0 as=0.12n ps=86u
M6144 OAI21X1_25/a_9_54# INVX2_73/Y vdd vdd pfet w=40 l=2
+  ad=0 pd=0 as=0 ps=0
M6145 OAI21X1_25/a_2_6# INVX2_22/Y gnd Gnd nfet w=20 l=2
+  ad=0 pd=0 as=0 ps=0
M6146 gnd NOR2X1_10/Y OAI21X1_14/a_2_6# Gnd nfet w=20 l=2
+  ad=0 pd=0 as=0.22n ps=0.102m
M6147 vdd NOR2X1_9/A INVX2_65/A vdd pfet w=20 l=2
+  ad=0 pd=0 as=0.22n ps=92u
M6148 INVX2_65/A NOR2X1_9/A OAI21X1_14/a_2_6# Gnd nfet w=20 l=2
+  ad=100p pd=50u as=0 ps=0
M6149 INVX2_65/A INVX2_64/Y OAI21X1_14/a_9_54# vdd pfet w=40 l=2
+  ad=0 pd=0 as=0.12n ps=86u
M6150 OAI21X1_14/a_9_54# NOR2X1_10/Y vdd vdd pfet w=40 l=2
+  ad=0 pd=0 as=0 ps=0
M6151 OAI21X1_14/a_2_6# INVX2_64/Y gnd Gnd nfet w=20 l=2
+  ad=0 pd=0 as=0 ps=0
M6152 gnd NAND2X1_2/Y OAI21X1_47/a_2_6# Gnd nfet w=20 l=2
+  ad=0 pd=0 as=0.22n ps=0.102m
M6153 vdd NAND2X1_7/Y OAI21X1_47/Y vdd pfet w=20 l=2
+  ad=0 pd=0 as=0.22n ps=92u
M6154 OAI21X1_47/Y NAND2X1_7/Y OAI21X1_47/a_2_6# Gnd nfet w=20 l=2
+  ad=100p pd=50u as=0 ps=0
M6155 OAI21X1_47/Y INVX2_23/Y OAI21X1_47/a_9_54# vdd pfet w=40 l=2
+  ad=0 pd=0 as=0.12n ps=86u
M6156 OAI21X1_47/a_9_54# NAND2X1_2/Y vdd vdd pfet w=40 l=2
+  ad=0 pd=0 as=0 ps=0
M6157 OAI21X1_47/a_2_6# INVX2_23/Y gnd Gnd nfet w=20 l=2
+  ad=0 pd=0 as=0 ps=0
M6158 gnd HAX1_1/YS OAI21X1_36/a_2_6# Gnd nfet w=20 l=2
+  ad=0 pd=0 as=0.22n ps=0.102m
M6159 vdd OAI21X1_36/C OAI21X1_36/Y vdd pfet w=20 l=2
+  ad=0 pd=0 as=0.22n ps=92u
M6160 OAI21X1_36/Y OAI21X1_36/C OAI21X1_36/a_2_6# Gnd nfet w=20 l=2
+  ad=100p pd=50u as=0 ps=0
M6161 OAI21X1_36/Y INVX2_175/Y OAI21X1_36/a_9_54# vdd pfet w=40 l=2
+  ad=0 pd=0 as=0.12n ps=86u
M6162 OAI21X1_36/a_9_54# HAX1_1/YS vdd vdd pfet w=40 l=2
+  ad=0 pd=0 as=0 ps=0
M6163 OAI21X1_36/a_2_6# INVX2_175/Y gnd Gnd nfet w=20 l=2
+  ad=0 pd=0 as=0 ps=0
M6164 gnd INVX2_149/A OAI21X1_58/a_2_6# Gnd nfet w=20 l=2
+  ad=0 pd=0 as=0.22n ps=0.102m
M6165 vdd OAI21X1_58/C OAI21X1_58/Y vdd pfet w=20 l=2
+  ad=0 pd=0 as=0.22n ps=92u
M6166 OAI21X1_58/Y OAI21X1_58/C OAI21X1_58/a_2_6# Gnd nfet w=20 l=2
+  ad=100p pd=50u as=0 ps=0
M6167 OAI21X1_58/Y AND2X2_7/B OAI21X1_58/a_9_54# vdd pfet w=40 l=2
+  ad=0 pd=0 as=0.12n ps=86u
M6168 OAI21X1_58/a_9_54# INVX2_149/A vdd vdd pfet w=40 l=2
+  ad=0 pd=0 as=0 ps=0
M6169 OAI21X1_58/a_2_6# AND2X2_7/B gnd Gnd nfet w=20 l=2
+  ad=0 pd=0 as=0 ps=0
M6170 gnd NOR2X1_32/B OAI21X1_69/a_2_6# Gnd nfet w=20 l=2
+  ad=0 pd=0 as=0.22n ps=0.102m
M6171 vdd NAND2X1_1/B NOR2X1_31/A vdd pfet w=20 l=2
+  ad=0 pd=0 as=0.22n ps=92u
M6172 NOR2X1_31/A NAND2X1_1/B OAI21X1_69/a_2_6# Gnd nfet w=20 l=2
+  ad=100p pd=50u as=0 ps=0
M6173 NOR2X1_31/A INVX2_26/A OAI21X1_69/a_9_54# vdd pfet w=40 l=2
+  ad=0 pd=0 as=0.12n ps=86u
M6174 OAI21X1_69/a_9_54# NOR2X1_32/B vdd vdd pfet w=40 l=2
+  ad=0 pd=0 as=0 ps=0
M6175 OAI21X1_69/a_2_6# INVX2_26/A gnd Gnd nfet w=20 l=2
+  ad=0 pd=0 as=0 ps=0
M6176 OR2X1_18/a_2_54# OR2X1_18/A gnd Gnd nfet w=10 l=2
+  ad=59.999996p pd=32u as=0 ps=0
M6177 OR2X1_18/Y OR2X1_18/a_2_54# vdd vdd pfet w=20 l=2
+  ad=100p pd=50u as=0 ps=0
M6178 OR2X1_18/Y OR2X1_18/a_2_54# gnd Gnd nfet w=10 l=2
+  ad=50p pd=30u as=0 ps=0
M6179 vdd OR2X1_18/B OR2X1_18/a_9_54# vdd pfet w=40 l=2
+  ad=0 pd=0 as=0.12n ps=86u
M6180 OR2X1_18/a_9_54# OR2X1_18/A OR2X1_18/a_2_54# vdd pfet w=40 l=2
+  ad=0 pd=0 as=0.2n ps=90u
M6181 gnd OR2X1_18/B OR2X1_18/a_2_54# Gnd nfet w=10 l=2
+  ad=0 pd=0 as=0 ps=0
M6182 AND2X2_17/a_2_6# AND2X2_18/Y vdd vdd pfet w=20 l=2
+  ad=0.12n pd=52u as=0 ps=0
M6183 AND2X2_17/a_9_6# AND2X2_18/Y AND2X2_17/a_2_6# Gnd nfet w=20 l=2
+  ad=59.999996p pd=46u as=100p ps=50u
M6184 AND2X2_17/Y AND2X2_17/a_2_6# gnd Gnd nfet w=20 l=2
+  ad=100p pd=50u as=0 ps=0
M6185 AND2X2_17/Y AND2X2_17/a_2_6# vdd vdd pfet w=40 l=2
+  ad=0.2n pd=90u as=0 ps=0
M6186 vdd INVX2_89/A AND2X2_17/a_2_6# vdd pfet w=20 l=2
+  ad=0 pd=0 as=0 ps=0
M6187 gnd INVX2_89/A AND2X2_17/a_9_6# Gnd nfet w=20 l=2
+  ad=0 pd=0 as=0 ps=0
M6188 gnd invader_2_coord_y[2] XNOR2X1_1/a_2_6# Gnd nfet w=20 l=2
+  ad=0 pd=0 as=100p ps=50u
M6189 XNOR2X1_1/Y invader_2_coord_y[2] XNOR2X1_1/a_18_6# Gnd nfet w=20 l=2
+  ad=0.2n pd=60u as=59.999996p ps=46u
M6190 XNOR2X1_1/a_12_41# invader_2_coord_y[1] gnd Gnd nfet w=20 l=2
+  ad=100p pd=50u as=0 ps=0
M6191 XNOR2X1_1/a_18_54# XNOR2X1_1/a_12_41# vdd vdd pfet w=40 l=2
+  ad=0.12n pd=86u as=0 ps=0
M6192 XNOR2X1_1/a_35_6# XNOR2X1_1/a_2_6# XNOR2X1_1/Y Gnd nfet w=20 l=2
+  ad=59.999996p pd=46u as=0 ps=0
M6193 XNOR2X1_1/a_18_6# XNOR2X1_1/a_12_41# gnd Gnd nfet w=20 l=2
+  ad=0 pd=0 as=0 ps=0
M6194 vdd invader_2_coord_y[2] XNOR2X1_1/a_2_6# vdd pfet w=40 l=2
+  ad=0 pd=0 as=0.2n ps=90u
M6195 vdd invader_2_coord_y[1] XNOR2X1_1/a_35_54# vdd pfet w=40 l=2
+  ad=0 pd=0 as=0.12n ps=86u
M6196 XNOR2X1_1/Y XNOR2X1_1/a_2_6# XNOR2X1_1/a_18_54# vdd pfet w=40 l=2
+  ad=0.4n pd=100u as=0 ps=0
M6197 XNOR2X1_1/a_35_54# invader_2_coord_y[2] XNOR2X1_1/Y vdd pfet w=40 l=2
+  ad=0 pd=0 as=0 ps=0
M6198 XNOR2X1_1/a_12_41# invader_2_coord_y[1] vdd vdd pfet w=40 l=2
+  ad=0.2n pd=90u as=0 ps=0
M6199 gnd invader_2_coord_y[1] XNOR2X1_1/a_35_6# Gnd nfet w=20 l=2
+  ad=0 pd=0 as=0 ps=0
M6200 DFFNEGX1_91/a_76_6# BUFX2_2/Y DFFNEGX1_91/a_66_6# Gnd nfet w=10 l=2
+  ad=29.999998p pd=26u as=80p ps=36u
M6201 gnd BUFX2_2/Y DFFNEGX1_91/a_2_6# Gnd nfet w=20 l=2
+  ad=0 pd=0 as=100p ps=50u
M6202 DFFNEGX1_91/a_66_6# DFFNEGX1_91/a_2_6# DFFNEGX1_91/a_61_6# Gnd nfet w=10 l=2
+  ad=0 pd=0 as=29.999998p ps=26u
M6203 INVX2_159/A DFFNEGX1_91/a_66_6# gnd Gnd nfet w=20 l=2
+  ad=100p pd=50u as=0 ps=0
M6204 DFFNEGX1_91/a_23_6# BUFX2_2/Y DFFNEGX1_91/a_17_6# Gnd nfet w=10 l=2
+  ad=59.999996p pd=32u as=40p ps=28u
M6205 DFFNEGX1_91/a_23_6# DFFNEGX1_91/a_2_6# DFFNEGX1_91/a_17_74# vdd pfet w=20 l=2
+  ad=0.12n pd=52u as=80p ps=48u
M6206 gnd DFFNEGX1_91/a_34_4# DFFNEGX1_91/a_31_6# Gnd nfet w=10 l=2
+  ad=0 pd=0 as=29.999998p ps=26u
M6207 vdd DFFNEGX1_91/a_34_4# DFFNEGX1_91/a_31_74# vdd pfet w=20 l=2
+  ad=0 pd=0 as=80p ps=48u
M6208 DFFNEGX1_91/a_61_74# DFFNEGX1_91/a_34_4# vdd vdd pfet w=20 l=2
+  ad=59.999996p pd=46u as=0 ps=0
M6209 DFFNEGX1_91/a_34_4# DFFNEGX1_91/a_23_6# vdd vdd pfet w=20 l=2
+  ad=100p pd=50u as=0 ps=0
M6210 DFFNEGX1_91/a_34_4# DFFNEGX1_91/a_23_6# gnd Gnd nfet w=10 l=2
+  ad=50p pd=30u as=0 ps=0
M6211 vdd INVX2_159/A DFFNEGX1_91/a_76_84# vdd pfet w=10 l=2
+  ad=0 pd=0 as=29.999998p ps=26u
M6212 gnd INVX2_159/A DFFNEGX1_91/a_76_6# Gnd nfet w=10 l=2
+  ad=0 pd=0 as=0 ps=0
M6213 DFFNEGX1_91/a_61_6# DFFNEGX1_91/a_34_4# gnd Gnd nfet w=10 l=2
+  ad=0 pd=0 as=0 ps=0
M6214 DFFNEGX1_91/a_76_84# DFFNEGX1_91/a_2_6# DFFNEGX1_91/a_66_6# vdd pfet w=10 l=2
+  ad=0 pd=0 as=0.15n ps=56u
M6215 INVX2_159/A DFFNEGX1_91/a_66_6# vdd vdd pfet w=40 l=2
+  ad=0.2n pd=90u as=0 ps=0
M6216 vdd BUFX2_2/Y DFFNEGX1_91/a_2_6# vdd pfet w=40 l=2
+  ad=0 pd=0 as=0.2n ps=90u
M6217 DFFNEGX1_91/a_31_6# DFFNEGX1_91/a_2_6# DFFNEGX1_91/a_23_6# Gnd nfet w=10 l=2
+  ad=0 pd=0 as=0 ps=0
M6218 DFFNEGX1_91/a_66_6# BUFX2_2/Y DFFNEGX1_91/a_61_74# vdd pfet w=20 l=2
+  ad=0 pd=0 as=0 ps=0
M6219 DFFNEGX1_91/a_17_74# INVX2_169/Y vdd vdd pfet w=20 l=2
+  ad=0 pd=0 as=0 ps=0
M6220 DFFNEGX1_91/a_31_74# BUFX2_2/Y DFFNEGX1_91/a_23_6# vdd pfet w=20 l=2
+  ad=0 pd=0 as=0 ps=0
M6221 DFFNEGX1_91/a_17_6# INVX2_169/Y gnd Gnd nfet w=10 l=2
+  ad=0 pd=0 as=0 ps=0
M6222 DFFNEGX1_80/a_76_6# BUFX2_2/Y DFFNEGX1_80/a_66_6# Gnd nfet w=10 l=2
+  ad=29.999998p pd=26u as=80p ps=36u
M6223 gnd BUFX2_2/Y DFFNEGX1_80/a_2_6# Gnd nfet w=20 l=2
+  ad=0 pd=0 as=100p ps=50u
M6224 DFFNEGX1_80/a_66_6# DFFNEGX1_80/a_2_6# DFFNEGX1_80/a_61_6# Gnd nfet w=10 l=2
+  ad=0 pd=0 as=29.999998p ps=26u
M6225 OR2X1_15/A DFFNEGX1_80/a_66_6# gnd Gnd nfet w=20 l=2
+  ad=100p pd=50u as=0 ps=0
M6226 DFFNEGX1_80/a_23_6# BUFX2_2/Y DFFNEGX1_80/a_17_6# Gnd nfet w=10 l=2
+  ad=59.999996p pd=32u as=40p ps=28u
M6227 DFFNEGX1_80/a_23_6# DFFNEGX1_80/a_2_6# DFFNEGX1_80/a_17_74# vdd pfet w=20 l=2
+  ad=0.12n pd=52u as=80p ps=48u
M6228 gnd DFFNEGX1_80/a_34_4# DFFNEGX1_80/a_31_6# Gnd nfet w=10 l=2
+  ad=0 pd=0 as=29.999998p ps=26u
M6229 vdd DFFNEGX1_80/a_34_4# DFFNEGX1_80/a_31_74# vdd pfet w=20 l=2
+  ad=0 pd=0 as=80p ps=48u
M6230 DFFNEGX1_80/a_61_74# DFFNEGX1_80/a_34_4# vdd vdd pfet w=20 l=2
+  ad=59.999996p pd=46u as=0 ps=0
M6231 DFFNEGX1_80/a_34_4# DFFNEGX1_80/a_23_6# vdd vdd pfet w=20 l=2
+  ad=100p pd=50u as=0 ps=0
M6232 DFFNEGX1_80/a_34_4# DFFNEGX1_80/a_23_6# gnd Gnd nfet w=10 l=2
+  ad=50p pd=30u as=0 ps=0
M6233 vdd OR2X1_15/A DFFNEGX1_80/a_76_84# vdd pfet w=10 l=2
+  ad=0 pd=0 as=29.999998p ps=26u
M6234 gnd OR2X1_15/A DFFNEGX1_80/a_76_6# Gnd nfet w=10 l=2
+  ad=0 pd=0 as=0 ps=0
M6235 DFFNEGX1_80/a_61_6# DFFNEGX1_80/a_34_4# gnd Gnd nfet w=10 l=2
+  ad=0 pd=0 as=0 ps=0
M6236 DFFNEGX1_80/a_76_84# DFFNEGX1_80/a_2_6# DFFNEGX1_80/a_66_6# vdd pfet w=10 l=2
+  ad=0 pd=0 as=0.15n ps=56u
M6237 OR2X1_15/A DFFNEGX1_80/a_66_6# vdd vdd pfet w=40 l=2
+  ad=0.2n pd=90u as=0 ps=0
M6238 vdd BUFX2_2/Y DFFNEGX1_80/a_2_6# vdd pfet w=40 l=2
+  ad=0 pd=0 as=0.2n ps=90u
M6239 DFFNEGX1_80/a_31_6# DFFNEGX1_80/a_2_6# DFFNEGX1_80/a_23_6# Gnd nfet w=10 l=2
+  ad=0 pd=0 as=0 ps=0
M6240 DFFNEGX1_80/a_66_6# BUFX2_2/Y DFFNEGX1_80/a_61_74# vdd pfet w=20 l=2
+  ad=0 pd=0 as=0 ps=0
M6241 DFFNEGX1_80/a_17_74# INVX2_167/Y vdd vdd pfet w=20 l=2
+  ad=0 pd=0 as=0 ps=0
M6242 DFFNEGX1_80/a_31_74# BUFX2_2/Y DFFNEGX1_80/a_23_6# vdd pfet w=20 l=2
+  ad=0 pd=0 as=0 ps=0
M6243 DFFNEGX1_80/a_17_6# INVX2_167/Y gnd Gnd nfet w=10 l=2
+  ad=0 pd=0 as=0 ps=0
M6244 vdd player_coord_x[1] HAX1_5/a_2_74# vdd pfet w=20 l=2
+  ad=0 pd=0 as=0.2n ps=100u
M6245 HAX1_5/a_41_74# HAX1_5/a_2_74# vdd vdd pfet w=20 l=2
+  ad=0.22n pd=92u as=0 ps=0
M6246 HAX1_5/a_9_6# player_coord_x[1] gnd Gnd nfet w=20 l=2
+  ad=59.999996p pd=46u as=0 ps=0
M6247 HAX1_5/a_41_74# player_coord_x[0] HAX1_5/a_38_6# Gnd nfet w=20 l=2
+  ad=0.12n pd=52u as=0.216n ps=0.102m
M6248 vdd player_coord_x[1] HAX1_5/a_49_54# vdd pfet w=40 l=2
+  ad=0 pd=0 as=0.12n ps=86u
M6249 vdd HAX1_5/a_2_74# HAX1_4/B vdd pfet w=20 l=2
+  ad=0 pd=0 as=100p ps=50u
M6250 HAX1_5/a_38_6# HAX1_5/a_2_74# gnd Gnd nfet w=20 l=2
+  ad=0 pd=0 as=0 ps=0
M6251 HAX1_5/YS HAX1_5/a_41_74# vdd vdd pfet w=20 l=2
+  ad=100p pd=50u as=0 ps=0
M6252 HAX1_5/a_38_6# player_coord_x[1] HAX1_5/a_41_74# Gnd nfet w=20 l=2
+  ad=0 pd=0 as=0 ps=0
M6253 HAX1_5/YS HAX1_5/a_41_74# gnd Gnd nfet w=10 l=2
+  ad=50p pd=30u as=0 ps=0
M6254 HAX1_5/a_2_74# player_coord_x[0] vdd vdd pfet w=20 l=2
+  ad=0 pd=0 as=0 ps=0
M6255 HAX1_5/a_2_74# player_coord_x[0] HAX1_5/a_9_6# Gnd nfet w=20 l=2
+  ad=100p pd=50u as=0 ps=0
M6256 HAX1_5/a_49_54# player_coord_x[0] HAX1_5/a_41_74# vdd pfet w=40 l=2
+  ad=0 pd=0 as=0 ps=0
M6257 gnd HAX1_5/a_2_74# HAX1_4/B Gnd nfet w=10 l=2
+  ad=0 pd=0 as=50p ps=30u
M6258 AND2X2_1/a_2_6# XOR2X1_0/A vdd vdd pfet w=20 l=2
+  ad=0.12n pd=52u as=0 ps=0
M6259 AND2X2_1/a_9_6# XOR2X1_0/A AND2X2_1/a_2_6# Gnd nfet w=20 l=2
+  ad=59.999996p pd=46u as=100p ps=50u
M6260 AND2X2_1/Y AND2X2_1/a_2_6# gnd Gnd nfet w=20 l=2
+  ad=100p pd=50u as=0 ps=0
M6261 AND2X2_1/Y AND2X2_1/a_2_6# vdd vdd pfet w=40 l=2
+  ad=0.2n pd=90u as=0 ps=0
M6262 vdd player_bullet_coord_x[3] AND2X2_1/a_2_6# vdd pfet w=20 l=2
+  ad=0 pd=0 as=0 ps=0
M6263 gnd player_bullet_coord_x[3] AND2X2_1/a_9_6# Gnd nfet w=20 l=2
+  ad=0 pd=0 as=0 ps=0
M6264 INVX2_134/A OAI21X1_99/B vdd vdd pfet w=20 l=2
+  ad=0.22n pd=0.102m as=0 ps=0
M6265 NAND3X1_39/a_9_6# OAI21X1_99/B gnd Gnd nfet w=30 l=2
+  ad=90p pd=66u as=0 ps=0
M6266 INVX2_134/A INVX2_89/Y vdd vdd pfet w=20 l=2
+  ad=0 pd=0 as=0 ps=0
M6267 INVX2_134/A INVX2_89/Y NAND3X1_39/a_14_6# Gnd nfet w=30 l=2
+  ad=0.15n pd=70u as=90p ps=66u
M6268 vdd INVX2_85/Y INVX2_134/A vdd pfet w=20 l=2
+  ad=0 pd=0 as=0 ps=0
M6269 NAND3X1_39/a_14_6# INVX2_85/Y NAND3X1_39/a_9_6# Gnd nfet w=30 l=2
+  ad=0 pd=0 as=0 ps=0
M6270 NAND3X1_28/Y OAI21X1_81/Y vdd vdd pfet w=20 l=2
+  ad=0.22n pd=0.102m as=0 ps=0
M6271 NAND3X1_28/a_9_6# OAI21X1_81/Y gnd Gnd nfet w=30 l=2
+  ad=90p pd=66u as=0 ps=0
M6272 NAND3X1_28/Y INVX2_135/Y vdd vdd pfet w=20 l=2
+  ad=0 pd=0 as=0 ps=0
M6273 NAND3X1_28/Y INVX2_135/Y NAND3X1_28/a_14_6# Gnd nfet w=30 l=2
+  ad=0.15n pd=70u as=90p ps=66u
M6274 vdd NAND3X1_29/Y NAND3X1_28/Y vdd pfet w=20 l=2
+  ad=0 pd=0 as=0 ps=0
M6275 NAND3X1_28/a_14_6# NAND3X1_29/Y NAND3X1_28/a_9_6# Gnd nfet w=30 l=2
+  ad=0 pd=0 as=0 ps=0
M6276 OAI21X1_57/C OAI22X1_4/B vdd vdd pfet w=20 l=2
+  ad=0.22n pd=0.102m as=0 ps=0
M6277 NAND3X1_17/a_9_6# OAI22X1_4/B gnd Gnd nfet w=30 l=2
+  ad=90p pd=66u as=0 ps=0
M6278 OAI21X1_57/C NOR2X1_32/B vdd vdd pfet w=20 l=2
+  ad=0 pd=0 as=0 ps=0
M6279 OAI21X1_57/C NOR2X1_32/B NAND3X1_17/a_14_6# Gnd nfet w=30 l=2
+  ad=0.15n pd=70u as=90p ps=66u
M6280 vdd NAND2X1_1/B OAI21X1_57/C vdd pfet w=20 l=2
+  ad=0 pd=0 as=0 ps=0
M6281 NAND3X1_17/a_14_6# NAND2X1_1/B NAND3X1_17/a_9_6# Gnd nfet w=30 l=2
+  ad=0 pd=0 as=0 ps=0
M6282 NOR2X1_28/Y NOR2X1_28/A gnd Gnd nfet w=10 l=2
+  ad=59.999996p pd=32u as=0 ps=0
M6283 NOR2X1_28/Y OR2X1_20/Y NOR2X1_28/a_9_54# vdd pfet w=40 l=2
+  ad=0.2n pd=90u as=0.12n ps=86u
M6284 NOR2X1_28/a_9_54# NOR2X1_28/A vdd vdd pfet w=40 l=2
+  ad=0 pd=0 as=0 ps=0
M6285 gnd OR2X1_20/Y NOR2X1_28/Y Gnd nfet w=10 l=2
+  ad=0 pd=0 as=0 ps=0
M6286 NOR2X1_17/Y invader_bullet_coord_y[1] gnd Gnd nfet w=10 l=2
+  ad=59.999996p pd=32u as=0 ps=0
M6287 NOR2X1_17/Y invader_bullet_coord_y[0] NOR2X1_17/a_9_54# vdd pfet w=40 l=2
+  ad=0.2n pd=90u as=0.12n ps=86u
M6288 NOR2X1_17/a_9_54# invader_bullet_coord_y[1] vdd vdd pfet w=40 l=2
+  ad=0 pd=0 as=0 ps=0
M6289 gnd invader_bullet_coord_y[0] NOR2X1_17/Y Gnd nfet w=10 l=2
+  ad=0 pd=0 as=0 ps=0
M6290 NOR2X1_39/Y OR2X1_15/A gnd Gnd nfet w=10 l=2
+  ad=59.999996p pd=32u as=0 ps=0
M6291 NOR2X1_39/Y INVX2_89/A NOR2X1_39/a_9_54# vdd pfet w=40 l=2
+  ad=0.2n pd=90u as=0.12n ps=86u
M6292 NOR2X1_39/a_9_54# OR2X1_15/A vdd vdd pfet w=40 l=2
+  ad=0 pd=0 as=0 ps=0
M6293 gnd INVX2_89/A NOR2X1_39/Y Gnd nfet w=10 l=2
+  ad=0 pd=0 as=0 ps=0
M6294 INVX2_89/A AND2X2_18/B vdd vdd pfet w=20 l=2
+  ad=0.12n pd=52u as=0 ps=0
M6295 NAND2X1_50/a_9_6# AND2X2_18/B gnd Gnd nfet w=20 l=2
+  ad=59.999996p pd=46u as=0 ps=0
M6296 vdd INVX2_88/Y INVX2_89/A vdd pfet w=20 l=2
+  ad=0 pd=0 as=0 ps=0
M6297 INVX2_89/A INVX2_88/Y NAND2X1_50/a_9_6# Gnd nfet w=20 l=2
+  ad=100p pd=50u as=0 ps=0
M6298 NAND2X1_5/B INVX2_12/Y vdd vdd pfet w=20 l=2
+  ad=0.12n pd=52u as=0 ps=0
M6299 NAND2X1_61/a_9_6# INVX2_12/Y gnd Gnd nfet w=20 l=2
+  ad=59.999996p pd=46u as=0 ps=0
M6300 vdd NAND2X1_8/Y NAND2X1_5/B vdd pfet w=20 l=2
+  ad=0 pd=0 as=0 ps=0
M6301 NAND2X1_5/B NAND2X1_8/Y NAND2X1_61/a_9_6# Gnd nfet w=20 l=2
+  ad=100p pd=50u as=0 ps=0
M6302 NOR2X1_60/B NOR2X1_54/A vdd vdd pfet w=20 l=2
+  ad=0.12n pd=52u as=0 ps=0
M6303 NAND2X1_83/a_9_6# NOR2X1_54/A gnd Gnd nfet w=20 l=2
+  ad=59.999996p pd=46u as=0 ps=0
M6304 vdd INVX2_165/Y NOR2X1_60/B vdd pfet w=20 l=2
+  ad=0 pd=0 as=0 ps=0
M6305 NOR2X1_60/B INVX2_165/Y NAND2X1_83/a_9_6# Gnd nfet w=20 l=2
+  ad=100p pd=50u as=0 ps=0
M6306 INVX2_101/A invader_2_coord_x[0] vdd vdd pfet w=20 l=2
+  ad=0.12n pd=52u as=0 ps=0
M6307 NAND2X1_72/a_9_6# invader_2_coord_x[0] gnd Gnd nfet w=20 l=2
+  ad=59.999996p pd=46u as=0 ps=0
M6308 vdd INVX2_176/Y INVX2_101/A vdd pfet w=20 l=2
+  ad=0 pd=0 as=0 ps=0
M6309 INVX2_101/A INVX2_176/Y NAND2X1_72/a_9_6# Gnd nfet w=20 l=2
+  ad=100p pd=50u as=0 ps=0
M6310 INVX2_30/Y INVX2_30/A gnd Gnd nfet w=20 l=2
+  ad=100p pd=50u as=0 ps=0
M6311 INVX2_30/Y INVX2_30/A vdd vdd pfet w=40 l=2
+  ad=0.2n pd=90u as=0 ps=0
M6312 INVX2_52/Y NOR2X1_5/Y gnd Gnd nfet w=20 l=2
+  ad=100p pd=50u as=0 ps=0
M6313 INVX2_52/Y NOR2X1_5/Y vdd vdd pfet w=40 l=2
+  ad=0.2n pd=90u as=0 ps=0
M6314 INVX2_41/Y INVX2_41/A gnd Gnd nfet w=20 l=2
+  ad=100p pd=50u as=0 ps=0
M6315 INVX2_41/Y INVX2_41/A vdd vdd pfet w=40 l=2
+  ad=0.2n pd=90u as=0 ps=0
M6316 INVX2_63/Y INVX2_63/A gnd Gnd nfet w=20 l=2
+  ad=100p pd=50u as=0 ps=0
M6317 INVX2_63/Y INVX2_63/A vdd vdd pfet w=40 l=2
+  ad=0.2n pd=90u as=0 ps=0
M6318 INVX2_85/Y shield_hp[0] gnd Gnd nfet w=20 l=2
+  ad=100p pd=50u as=0 ps=0
M6319 INVX2_85/Y shield_hp[0] vdd vdd pfet w=40 l=2
+  ad=0.2n pd=90u as=0 ps=0
M6320 INVX2_96/Y INVX2_96/A gnd Gnd nfet w=20 l=2
+  ad=100p pd=50u as=0 ps=0
M6321 INVX2_96/Y INVX2_96/A vdd vdd pfet w=40 l=2
+  ad=0.2n pd=90u as=0 ps=0
M6322 INVX2_74/Y invader_1_coord_y[2] gnd Gnd nfet w=20 l=2
+  ad=100p pd=50u as=0 ps=0
M6323 INVX2_74/Y invader_1_coord_y[2] vdd vdd pfet w=40 l=2
+  ad=0.2n pd=90u as=0 ps=0
M6324 gnd player_bullet_coord_y[2] OAI21X1_26/a_2_6# Gnd nfet w=20 l=2
+  ad=0 pd=0 as=0.22n ps=0.102m
M6325 vdd NAND3X1_8/A OAI21X1_26/Y vdd pfet w=20 l=2
+  ad=0 pd=0 as=0.22n ps=92u
M6326 OAI21X1_26/Y NAND3X1_8/A OAI21X1_26/a_2_6# Gnd nfet w=20 l=2
+  ad=100p pd=50u as=0 ps=0
M6327 OAI21X1_26/Y INVX2_75/Y OAI21X1_26/a_9_54# vdd pfet w=40 l=2
+  ad=0 pd=0 as=0.12n ps=86u
M6328 OAI21X1_26/a_9_54# player_bullet_coord_y[2] vdd vdd pfet w=40 l=2
+  ad=0 pd=0 as=0 ps=0
M6329 OAI21X1_26/a_2_6# INVX2_75/Y gnd Gnd nfet w=20 l=2
+  ad=0 pd=0 as=0 ps=0
M6330 gnd HAX1_10/YS OAI21X1_15/a_2_6# Gnd nfet w=20 l=2
+  ad=0 pd=0 as=0.22n ps=0.102m
M6331 vdd NAND3X1_5/A AOI22X1_4/D vdd pfet w=20 l=2
+  ad=0 pd=0 as=0.22n ps=92u
M6332 AOI22X1_4/D NAND3X1_5/A OAI21X1_15/a_2_6# Gnd nfet w=20 l=2
+  ad=100p pd=50u as=0 ps=0
M6333 AOI22X1_4/D INVX2_19/Y OAI21X1_15/a_9_54# vdd pfet w=40 l=2
+  ad=0 pd=0 as=0.12n ps=86u
M6334 OAI21X1_15/a_9_54# HAX1_10/YS vdd vdd pfet w=40 l=2
+  ad=0 pd=0 as=0 ps=0
M6335 OAI21X1_15/a_2_6# INVX2_19/Y gnd Gnd nfet w=20 l=2
+  ad=0 pd=0 as=0 ps=0
M6336 gnd NOR2X1_24/Y OAI21X1_48/a_2_6# Gnd nfet w=20 l=2
+  ad=0 pd=0 as=0.22n ps=0.102m
M6337 vdd OAI21X1_48/C AND2X2_0/B vdd pfet w=20 l=2
+  ad=0 pd=0 as=0.22n ps=92u
M6338 AND2X2_0/B OAI21X1_48/C OAI21X1_48/a_2_6# Gnd nfet w=20 l=2
+  ad=100p pd=50u as=0 ps=0
M6339 AND2X2_0/B INVX2_15/Y OAI21X1_48/a_9_54# vdd pfet w=40 l=2
+  ad=0 pd=0 as=0.12n ps=86u
M6340 OAI21X1_48/a_9_54# NOR2X1_24/Y vdd vdd pfet w=40 l=2
+  ad=0 pd=0 as=0 ps=0
M6341 OAI21X1_48/a_2_6# INVX2_15/Y gnd Gnd nfet w=20 l=2
+  ad=0 pd=0 as=0 ps=0
M6342 gnd player_coord_x[3] OAI21X1_37/a_2_6# Gnd nfet w=20 l=2
+  ad=0 pd=0 as=0.22n ps=0.102m
M6343 vdd OAI21X1_37/C INVX2_105/A vdd pfet w=20 l=2
+  ad=0 pd=0 as=0.22n ps=92u
M6344 INVX2_105/A OAI21X1_37/C OAI21X1_37/a_2_6# Gnd nfet w=20 l=2
+  ad=100p pd=50u as=0 ps=0
M6345 INVX2_105/A INVX2_9/Y OAI21X1_37/a_9_54# vdd pfet w=40 l=2
+  ad=0 pd=0 as=0.12n ps=86u
M6346 OAI21X1_37/a_9_54# player_coord_x[3] vdd vdd pfet w=40 l=2
+  ad=0 pd=0 as=0 ps=0
M6347 OAI21X1_37/a_2_6# INVX2_9/Y gnd Gnd nfet w=20 l=2
+  ad=0 pd=0 as=0 ps=0
M6348 gnd OAI21X1_59/A OAI21X1_59/a_2_6# Gnd nfet w=20 l=2
+  ad=0 pd=0 as=0.22n ps=0.102m
M6349 vdd INVX2_138/Y OAI21X1_59/Y vdd pfet w=20 l=2
+  ad=0 pd=0 as=0.22n ps=92u
M6350 OAI21X1_59/Y INVX2_138/Y OAI21X1_59/a_2_6# Gnd nfet w=20 l=2
+  ad=100p pd=50u as=0 ps=0
M6351 OAI21X1_59/Y INVX2_29/Y OAI21X1_59/a_9_54# vdd pfet w=40 l=2
+  ad=0 pd=0 as=0.12n ps=86u
M6352 OAI21X1_59/a_9_54# OAI21X1_59/A vdd vdd pfet w=40 l=2
+  ad=0 pd=0 as=0 ps=0
M6353 OAI21X1_59/a_2_6# INVX2_29/Y gnd Gnd nfet w=20 l=2
+  ad=0 pd=0 as=0 ps=0
M6354 OR2X1_19/a_2_54# invader_1_display gnd Gnd nfet w=10 l=2
+  ad=59.999996p pd=32u as=0 ps=0
M6355 OR2X1_19/Y OR2X1_19/a_2_54# vdd vdd pfet w=20 l=2
+  ad=100p pd=50u as=0 ps=0
M6356 OR2X1_19/Y OR2X1_19/a_2_54# gnd Gnd nfet w=10 l=2
+  ad=50p pd=30u as=0 ps=0
M6357 vdd invader_2_display OR2X1_19/a_9_54# vdd pfet w=40 l=2
+  ad=0 pd=0 as=0.12n ps=86u
M6358 OR2X1_19/a_9_54# invader_1_display OR2X1_19/a_2_54# vdd pfet w=40 l=2
+  ad=0 pd=0 as=0.2n ps=90u
M6359 gnd invader_2_display OR2X1_19/a_2_54# Gnd nfet w=10 l=2
+  ad=0 pd=0 as=0 ps=0
M6360 AND2X2_18/a_2_6# INVX2_133/Y vdd vdd pfet w=20 l=2
+  ad=0.12n pd=52u as=0 ps=0
M6361 AND2X2_18/a_9_6# INVX2_133/Y AND2X2_18/a_2_6# Gnd nfet w=20 l=2
+  ad=59.999996p pd=46u as=100p ps=50u
M6362 AND2X2_18/Y AND2X2_18/a_2_6# gnd Gnd nfet w=20 l=2
+  ad=100p pd=50u as=0 ps=0
M6363 AND2X2_18/Y AND2X2_18/a_2_6# vdd vdd pfet w=40 l=2
+  ad=0.2n pd=90u as=0 ps=0
M6364 vdd AND2X2_18/B AND2X2_18/a_2_6# vdd pfet w=20 l=2
+  ad=0 pd=0 as=0 ps=0
M6365 gnd AND2X2_18/B AND2X2_18/a_9_6# Gnd nfet w=20 l=2
+  ad=0 pd=0 as=0 ps=0
M6366 gnd invader_1_coord_y[2] XNOR2X1_2/a_2_6# Gnd nfet w=20 l=2
+  ad=0 pd=0 as=100p ps=50u
M6367 XNOR2X1_2/Y invader_1_coord_y[2] XNOR2X1_2/a_18_6# Gnd nfet w=20 l=2
+  ad=0.2n pd=60u as=59.999996p ps=46u
M6368 XNOR2X1_2/a_12_41# invader_1_coord_y[1] gnd Gnd nfet w=20 l=2
+  ad=100p pd=50u as=0 ps=0
M6369 XNOR2X1_2/a_18_54# XNOR2X1_2/a_12_41# vdd vdd pfet w=40 l=2
+  ad=0.12n pd=86u as=0 ps=0
M6370 XNOR2X1_2/a_35_6# XNOR2X1_2/a_2_6# XNOR2X1_2/Y Gnd nfet w=20 l=2
+  ad=59.999996p pd=46u as=0 ps=0
M6371 XNOR2X1_2/a_18_6# XNOR2X1_2/a_12_41# gnd Gnd nfet w=20 l=2
+  ad=0 pd=0 as=0 ps=0
M6372 vdd invader_1_coord_y[2] XNOR2X1_2/a_2_6# vdd pfet w=40 l=2
+  ad=0 pd=0 as=0.2n ps=90u
M6373 vdd invader_1_coord_y[1] XNOR2X1_2/a_35_54# vdd pfet w=40 l=2
+  ad=0 pd=0 as=0.12n ps=86u
M6374 XNOR2X1_2/Y XNOR2X1_2/a_2_6# XNOR2X1_2/a_18_54# vdd pfet w=40 l=2
+  ad=0.4n pd=100u as=0 ps=0
M6375 XNOR2X1_2/a_35_54# invader_1_coord_y[2] XNOR2X1_2/Y vdd pfet w=40 l=2
+  ad=0 pd=0 as=0 ps=0
M6376 XNOR2X1_2/a_12_41# invader_1_coord_y[1] vdd vdd pfet w=40 l=2
+  ad=0.2n pd=90u as=0 ps=0
M6377 gnd invader_1_coord_y[1] XNOR2X1_2/a_35_6# Gnd nfet w=20 l=2
+  ad=0 pd=0 as=0 ps=0
M6378 DFFNEGX1_70/a_76_6# BUFX2_3/Y DFFNEGX1_70/a_66_6# Gnd nfet w=10 l=2
+  ad=29.999998p pd=26u as=80p ps=36u
M6379 gnd BUFX2_3/Y DFFNEGX1_70/a_2_6# Gnd nfet w=20 l=2
+  ad=0 pd=0 as=100p ps=50u
M6380 DFFNEGX1_70/a_66_6# DFFNEGX1_70/a_2_6# DFFNEGX1_70/a_61_6# Gnd nfet w=10 l=2
+  ad=0 pd=0 as=29.999998p ps=26u
M6381 OR2X1_15/B DFFNEGX1_70/a_66_6# gnd Gnd nfet w=20 l=2
+  ad=100p pd=50u as=0 ps=0
M6382 DFFNEGX1_70/a_23_6# BUFX2_3/Y DFFNEGX1_70/a_17_6# Gnd nfet w=10 l=2
+  ad=59.999996p pd=32u as=40p ps=28u
M6383 DFFNEGX1_70/a_23_6# DFFNEGX1_70/a_2_6# DFFNEGX1_70/a_17_74# vdd pfet w=20 l=2
+  ad=0.12n pd=52u as=80p ps=48u
M6384 gnd DFFNEGX1_70/a_34_4# DFFNEGX1_70/a_31_6# Gnd nfet w=10 l=2
+  ad=0 pd=0 as=29.999998p ps=26u
M6385 vdd DFFNEGX1_70/a_34_4# DFFNEGX1_70/a_31_74# vdd pfet w=20 l=2
+  ad=0 pd=0 as=80p ps=48u
M6386 DFFNEGX1_70/a_61_74# DFFNEGX1_70/a_34_4# vdd vdd pfet w=20 l=2
+  ad=59.999996p pd=46u as=0 ps=0
M6387 DFFNEGX1_70/a_34_4# DFFNEGX1_70/a_23_6# vdd vdd pfet w=20 l=2
+  ad=100p pd=50u as=0 ps=0
M6388 DFFNEGX1_70/a_34_4# DFFNEGX1_70/a_23_6# gnd Gnd nfet w=10 l=2
+  ad=50p pd=30u as=0 ps=0
M6389 vdd OR2X1_15/B DFFNEGX1_70/a_76_84# vdd pfet w=10 l=2
+  ad=0 pd=0 as=29.999998p ps=26u
M6390 gnd OR2X1_15/B DFFNEGX1_70/a_76_6# Gnd nfet w=10 l=2
+  ad=0 pd=0 as=0 ps=0
M6391 DFFNEGX1_70/a_61_6# DFFNEGX1_70/a_34_4# gnd Gnd nfet w=10 l=2
+  ad=0 pd=0 as=0 ps=0
M6392 DFFNEGX1_70/a_76_84# DFFNEGX1_70/a_2_6# DFFNEGX1_70/a_66_6# vdd pfet w=10 l=2
+  ad=0 pd=0 as=0.15n ps=56u
M6393 OR2X1_15/B DFFNEGX1_70/a_66_6# vdd vdd pfet w=40 l=2
+  ad=0.2n pd=90u as=0 ps=0
M6394 vdd BUFX2_3/Y DFFNEGX1_70/a_2_6# vdd pfet w=40 l=2
+  ad=0 pd=0 as=0.2n ps=90u
M6395 DFFNEGX1_70/a_31_6# DFFNEGX1_70/a_2_6# DFFNEGX1_70/a_23_6# Gnd nfet w=10 l=2
+  ad=0 pd=0 as=0 ps=0
M6396 DFFNEGX1_70/a_66_6# BUFX2_3/Y DFFNEGX1_70/a_61_74# vdd pfet w=20 l=2
+  ad=0 pd=0 as=0 ps=0
M6397 DFFNEGX1_70/a_17_74# NOR2X1_47/Y vdd vdd pfet w=20 l=2
+  ad=0 pd=0 as=0 ps=0
M6398 DFFNEGX1_70/a_31_74# BUFX2_3/Y DFFNEGX1_70/a_23_6# vdd pfet w=20 l=2
+  ad=0 pd=0 as=0 ps=0
M6399 DFFNEGX1_70/a_17_6# NOR2X1_47/Y gnd Gnd nfet w=10 l=2
+  ad=0 pd=0 as=0 ps=0
M6400 DFFNEGX1_81/a_76_6# BUFX2_2/Y DFFNEGX1_81/a_66_6# Gnd nfet w=10 l=2
+  ad=29.999998p pd=26u as=80p ps=36u
M6401 gnd BUFX2_2/Y DFFNEGX1_81/a_2_6# Gnd nfet w=20 l=2
+  ad=0 pd=0 as=100p ps=50u
M6402 DFFNEGX1_81/a_66_6# DFFNEGX1_81/a_2_6# DFFNEGX1_81/a_61_6# Gnd nfet w=10 l=2
+  ad=0 pd=0 as=29.999998p ps=26u
M6403 INVX2_144/A DFFNEGX1_81/a_66_6# gnd Gnd nfet w=20 l=2
+  ad=100p pd=50u as=0 ps=0
M6404 DFFNEGX1_81/a_23_6# BUFX2_2/Y DFFNEGX1_81/a_17_6# Gnd nfet w=10 l=2
+  ad=59.999996p pd=32u as=40p ps=28u
M6405 DFFNEGX1_81/a_23_6# DFFNEGX1_81/a_2_6# DFFNEGX1_81/a_17_74# vdd pfet w=20 l=2
+  ad=0.12n pd=52u as=80p ps=48u
M6406 gnd DFFNEGX1_81/a_34_4# DFFNEGX1_81/a_31_6# Gnd nfet w=10 l=2
+  ad=0 pd=0 as=29.999998p ps=26u
M6407 vdd DFFNEGX1_81/a_34_4# DFFNEGX1_81/a_31_74# vdd pfet w=20 l=2
+  ad=0 pd=0 as=80p ps=48u
M6408 DFFNEGX1_81/a_61_74# DFFNEGX1_81/a_34_4# vdd vdd pfet w=20 l=2
+  ad=59.999996p pd=46u as=0 ps=0
M6409 DFFNEGX1_81/a_34_4# DFFNEGX1_81/a_23_6# vdd vdd pfet w=20 l=2
+  ad=100p pd=50u as=0 ps=0
M6410 DFFNEGX1_81/a_34_4# DFFNEGX1_81/a_23_6# gnd Gnd nfet w=10 l=2
+  ad=50p pd=30u as=0 ps=0
M6411 vdd INVX2_144/A DFFNEGX1_81/a_76_84# vdd pfet w=10 l=2
+  ad=0 pd=0 as=29.999998p ps=26u
M6412 gnd INVX2_144/A DFFNEGX1_81/a_76_6# Gnd nfet w=10 l=2
+  ad=0 pd=0 as=0 ps=0
M6413 DFFNEGX1_81/a_61_6# DFFNEGX1_81/a_34_4# gnd Gnd nfet w=10 l=2
+  ad=0 pd=0 as=0 ps=0
M6414 DFFNEGX1_81/a_76_84# DFFNEGX1_81/a_2_6# DFFNEGX1_81/a_66_6# vdd pfet w=10 l=2
+  ad=0 pd=0 as=0.15n ps=56u
M6415 INVX2_144/A DFFNEGX1_81/a_66_6# vdd vdd pfet w=40 l=2
+  ad=0.2n pd=90u as=0 ps=0
M6416 vdd BUFX2_2/Y DFFNEGX1_81/a_2_6# vdd pfet w=40 l=2
+  ad=0 pd=0 as=0.2n ps=90u
M6417 DFFNEGX1_81/a_31_6# DFFNEGX1_81/a_2_6# DFFNEGX1_81/a_23_6# Gnd nfet w=10 l=2
+  ad=0 pd=0 as=0 ps=0
M6418 DFFNEGX1_81/a_66_6# BUFX2_2/Y DFFNEGX1_81/a_61_74# vdd pfet w=20 l=2
+  ad=0 pd=0 as=0 ps=0
M6419 DFFNEGX1_81/a_17_74# OAI21X1_123/Y vdd vdd pfet w=20 l=2
+  ad=0 pd=0 as=0 ps=0
M6420 DFFNEGX1_81/a_31_74# BUFX2_2/Y DFFNEGX1_81/a_23_6# vdd pfet w=20 l=2
+  ad=0 pd=0 as=0 ps=0
M6421 DFFNEGX1_81/a_17_6# OAI21X1_123/Y gnd Gnd nfet w=10 l=2
+  ad=0 pd=0 as=0 ps=0
M6422 vdd invader_1_coord_y[3] HAX1_6/a_2_74# vdd pfet w=20 l=2
+  ad=0 pd=0 as=0.2n ps=100u
M6423 HAX1_6/a_41_74# HAX1_6/a_2_74# vdd vdd pfet w=20 l=2
+  ad=0.22n pd=92u as=0 ps=0
M6424 HAX1_6/a_9_6# invader_1_coord_y[3] gnd Gnd nfet w=20 l=2
+  ad=59.999996p pd=46u as=0 ps=0
M6425 HAX1_6/a_41_74# HAX1_6/B HAX1_6/a_38_6# Gnd nfet w=20 l=2
+  ad=0.12n pd=52u as=0.216n ps=0.102m
M6426 vdd invader_1_coord_y[3] HAX1_6/a_49_54# vdd pfet w=40 l=2
+  ad=0 pd=0 as=0.12n ps=86u
M6427 vdd HAX1_6/a_2_74# OR2X1_3/B vdd pfet w=20 l=2
+  ad=0 pd=0 as=100p ps=50u
M6428 HAX1_6/a_38_6# HAX1_6/a_2_74# gnd Gnd nfet w=20 l=2
+  ad=0 pd=0 as=0 ps=0
M6429 HAX1_6/YS HAX1_6/a_41_74# vdd vdd pfet w=20 l=2
+  ad=100p pd=50u as=0 ps=0
M6430 HAX1_6/a_38_6# invader_1_coord_y[3] HAX1_6/a_41_74# Gnd nfet w=20 l=2
+  ad=0 pd=0 as=0 ps=0
M6431 HAX1_6/YS HAX1_6/a_41_74# gnd Gnd nfet w=10 l=2
+  ad=50p pd=30u as=0 ps=0
M6432 HAX1_6/a_2_74# HAX1_6/B vdd vdd pfet w=20 l=2
+  ad=0 pd=0 as=0 ps=0
M6433 HAX1_6/a_2_74# HAX1_6/B HAX1_6/a_9_6# Gnd nfet w=20 l=2
+  ad=100p pd=50u as=0 ps=0
M6434 HAX1_6/a_49_54# HAX1_6/B HAX1_6/a_41_74# vdd pfet w=40 l=2
+  ad=0 pd=0 as=0 ps=0
M6435 gnd HAX1_6/a_2_74# OR2X1_3/B Gnd nfet w=10 l=2
+  ad=0 pd=0 as=50p ps=30u
M6436 AND2X2_2/a_2_6# XOR2X1_2/A vdd vdd pfet w=20 l=2
+  ad=0.12n pd=52u as=0 ps=0
M6437 AND2X2_2/a_9_6# XOR2X1_2/A AND2X2_2/a_2_6# Gnd nfet w=20 l=2
+  ad=59.999996p pd=46u as=100p ps=50u
M6438 AND2X2_2/Y AND2X2_2/a_2_6# gnd Gnd nfet w=20 l=2
+  ad=100p pd=50u as=0 ps=0
M6439 AND2X2_2/Y AND2X2_2/a_2_6# vdd vdd pfet w=40 l=2
+  ad=0.2n pd=90u as=0 ps=0
M6440 vdd invader_bullet_coord_x[3] AND2X2_2/a_2_6# vdd pfet w=20 l=2
+  ad=0 pd=0 as=0 ps=0
M6441 gnd invader_bullet_coord_x[3] AND2X2_2/a_9_6# Gnd nfet w=20 l=2
+  ad=0 pd=0 as=0 ps=0
M6442 NAND3X1_18/Y OAI21X1_61/Y vdd vdd pfet w=20 l=2
+  ad=0.22n pd=0.102m as=0 ps=0
M6443 NAND3X1_18/a_9_6# OAI21X1_61/Y gnd Gnd nfet w=30 l=2
+  ad=90p pd=66u as=0 ps=0
M6444 NAND3X1_18/Y INVX2_138/Y vdd vdd pfet w=20 l=2
+  ad=0 pd=0 as=0 ps=0
M6445 NAND3X1_18/Y INVX2_138/Y NAND3X1_18/a_14_6# Gnd nfet w=30 l=2
+  ad=0.15n pd=70u as=90p ps=66u
M6446 vdd NAND3X1_19/Y NAND3X1_18/Y vdd pfet w=20 l=2
+  ad=0 pd=0 as=0 ps=0
M6447 NAND3X1_18/a_14_6# NAND3X1_19/Y NAND3X1_18/a_9_6# Gnd nfet w=30 l=2
+  ad=0 pd=0 as=0 ps=0
M6448 NAND3X1_29/Y INVX2_71/Y vdd vdd pfet w=20 l=2
+  ad=0.22n pd=0.102m as=0 ps=0
M6449 NAND3X1_29/a_9_6# INVX2_71/Y gnd Gnd nfet w=30 l=2
+  ad=90p pd=66u as=0 ps=0
M6450 NAND3X1_29/Y INVX2_145/Y vdd vdd pfet w=20 l=2
+  ad=0 pd=0 as=0 ps=0
M6451 NAND3X1_29/Y INVX2_145/Y NAND3X1_29/a_14_6# Gnd nfet w=30 l=2
+  ad=0.15n pd=70u as=90p ps=66u
M6452 vdd INVX2_76/Y NAND3X1_29/Y vdd pfet w=20 l=2
+  ad=0 pd=0 as=0 ps=0
M6453 NAND3X1_29/a_14_6# INVX2_76/Y NAND3X1_29/a_9_6# Gnd nfet w=30 l=2
+  ad=0 pd=0 as=0 ps=0
M6454 NOR2X1_18/Y INVX2_2/Y gnd Gnd nfet w=10 l=2
+  ad=59.999996p pd=32u as=0 ps=0
M6455 NOR2X1_18/Y OR2X1_15/A NOR2X1_18/a_9_54# vdd pfet w=40 l=2
+  ad=0.2n pd=90u as=0.12n ps=86u
M6456 NOR2X1_18/a_9_54# INVX2_2/Y vdd vdd pfet w=40 l=2
+  ad=0 pd=0 as=0 ps=0
M6457 gnd OR2X1_15/A NOR2X1_18/Y Gnd nfet w=10 l=2
+  ad=0 pd=0 as=0 ps=0
M6458 AND2X2_9/A OAI22X1_4/D gnd Gnd nfet w=10 l=2
+  ad=59.999996p pd=32u as=0 ps=0
M6459 AND2X2_9/A NOR2X1_29/B NOR2X1_29/a_9_54# vdd pfet w=40 l=2
+  ad=0.2n pd=90u as=0.12n ps=86u
M6460 NOR2X1_29/a_9_54# OAI22X1_4/D vdd vdd pfet w=40 l=2
+  ad=0 pd=0 as=0 ps=0
M6461 gnd NOR2X1_29/B AND2X2_9/A Gnd nfet w=10 l=2
+  ad=0 pd=0 as=0 ps=0
M6462 NAND2X1_51/Y NOR2X1_44/Y vdd vdd pfet w=20 l=2
+  ad=0.12n pd=52u as=0 ps=0
M6463 NAND2X1_51/a_9_6# NOR2X1_44/Y gnd Gnd nfet w=20 l=2
+  ad=59.999996p pd=46u as=0 ps=0
M6464 vdd INVX2_97/A NAND2X1_51/Y vdd pfet w=20 l=2
+  ad=0 pd=0 as=0 ps=0
M6465 NAND2X1_51/Y INVX2_97/A NAND2X1_51/a_9_6# Gnd nfet w=20 l=2
+  ad=100p pd=50u as=0 ps=0
M6466 OAI21X1_74/C OR2X1_20/A vdd vdd pfet w=20 l=2
+  ad=0.12n pd=52u as=0 ps=0
M6467 NAND2X1_40/a_9_6# OR2X1_20/A gnd Gnd nfet w=20 l=2
+  ad=59.999996p pd=46u as=0 ps=0
M6468 vdd INVX2_136/Y OAI21X1_74/C vdd pfet w=20 l=2
+  ad=0 pd=0 as=0 ps=0
M6469 OAI21X1_74/C INVX2_136/Y NAND2X1_40/a_9_6# Gnd nfet w=20 l=2
+  ad=100p pd=50u as=0 ps=0
M6470 NAND2X1_62/Y INVX2_144/A vdd vdd pfet w=20 l=2
+  ad=0.12n pd=52u as=0 ps=0
M6471 NAND2X1_62/a_9_6# INVX2_144/A gnd Gnd nfet w=20 l=2
+  ad=59.999996p pd=46u as=0 ps=0
M6472 vdd NOR2X1_54/Y NAND2X1_62/Y vdd pfet w=20 l=2
+  ad=0 pd=0 as=0 ps=0
M6473 NAND2X1_62/Y NOR2X1_54/Y NAND2X1_62/a_9_6# Gnd nfet w=20 l=2
+  ad=100p pd=50u as=0 ps=0
M6474 INVX2_127/A INVX2_128/A vdd vdd pfet w=20 l=2
+  ad=0.12n pd=52u as=0 ps=0
M6475 NAND2X1_84/a_9_6# INVX2_128/A gnd Gnd nfet w=20 l=2
+  ad=59.999996p pd=46u as=0 ps=0
M6476 vdd NOR2X1_60/A INVX2_127/A vdd pfet w=20 l=2
+  ad=0 pd=0 as=0 ps=0
M6477 INVX2_127/A NOR2X1_60/A NAND2X1_84/a_9_6# Gnd nfet w=20 l=2
+  ad=100p pd=50u as=0 ps=0
M6478 NAND2X1_73/Y NOR2X1_56/B vdd vdd pfet w=20 l=2
+  ad=0.12n pd=52u as=0 ps=0
M6479 NAND2X1_73/a_9_6# NOR2X1_56/B gnd Gnd nfet w=20 l=2
+  ad=59.999996p pd=46u as=0 ps=0
M6480 vdd NAND2X1_73/B NAND2X1_73/Y vdd pfet w=20 l=2
+  ad=0 pd=0 as=0 ps=0
M6481 NAND2X1_73/Y NAND2X1_73/B NAND2X1_73/a_9_6# Gnd nfet w=20 l=2
+  ad=100p pd=50u as=0 ps=0
M6482 gnd AOI22X1_60/C AOI22X1_60/a_28_6# Gnd nfet w=20 l=2
+  ad=0 pd=0 as=59.999996p ps=46u
M6483 NAND2X1_71/A INVX2_106/Y AOI22X1_60/a_11_6# Gnd nfet w=20 l=2
+  ad=0.2n pd=60u as=59.999996p ps=46u
M6484 AOI22X1_60/a_11_6# NOR2X1_56/Y gnd Gnd nfet w=20 l=2
+  ad=0 pd=0 as=0 ps=0
M6485 AOI22X1_60/a_2_54# INVX2_106/Y vdd vdd pfet w=40 l=2
+  ad=0.64n pd=0.272m as=0 ps=0
M6486 AOI22X1_60/a_28_6# XOR2X1_19/Y NAND2X1_71/A Gnd nfet w=20 l=2
+  ad=0 pd=0 as=0 ps=0
M6487 vdd NOR2X1_56/Y AOI22X1_60/a_2_54# vdd pfet w=40 l=2
+  ad=0 pd=0 as=0 ps=0
M6488 NAND2X1_71/A XOR2X1_19/Y AOI22X1_60/a_2_54# vdd pfet w=40 l=2
+  ad=0.24n pd=92u as=0 ps=0
M6489 AOI22X1_60/a_2_54# AOI22X1_60/C NAND2X1_71/A vdd pfet w=40 l=2
+  ad=0 pd=0 as=0 ps=0
M6490 gnd player_bullet_coord_x[1] OAI22X1_0/a_2_6# Gnd nfet w=20 l=2
+  ad=0 pd=0 as=0.32n ps=0.152m
M6491 OAI22X1_0/a_2_6# player_bullet_coord_x[0] OAI22X1_0/Y Gnd nfet w=20 l=2
+  ad=0 pd=0 as=0.12n ps=52u
M6492 OAI22X1_0/Y invader_2_coord_x[0] OAI22X1_0/a_2_6# Gnd nfet w=20 l=2
+  ad=0 pd=0 as=0 ps=0
M6493 OAI22X1_0/Y INVX2_47/A OAI22X1_0/a_9_54# vdd pfet w=40 l=2
+  ad=0.48n pd=0.104m as=0.12n ps=86u
M6494 OAI22X1_0/a_28_54# invader_2_coord_x[0] OAI22X1_0/Y vdd pfet w=40 l=2
+  ad=0.12n pd=86u as=0 ps=0
M6495 OAI22X1_0/a_9_54# player_bullet_coord_x[1] vdd vdd pfet w=40 l=2
+  ad=0 pd=0 as=0 ps=0
M6496 OAI22X1_0/a_2_6# INVX2_47/A gnd Gnd nfet w=20 l=2
+  ad=0 pd=0 as=0 ps=0
M6497 vdd player_bullet_coord_x[0] OAI22X1_0/a_28_54# vdd pfet w=40 l=2
+  ad=0 pd=0 as=0 ps=0
M6498 INVX2_20/Y XOR2X1_1/Y gnd Gnd nfet w=20 l=2
+  ad=100p pd=50u as=0 ps=0
M6499 INVX2_20/Y XOR2X1_1/Y vdd vdd pfet w=40 l=2
+  ad=0.2n pd=90u as=0 ps=0
M6500 INVX2_42/Y INVX2_42/A gnd Gnd nfet w=20 l=2
+  ad=100p pd=50u as=0 ps=0
M6501 INVX2_42/Y INVX2_42/A vdd vdd pfet w=40 l=2
+  ad=0.2n pd=90u as=0 ps=0
M6502 INVX2_31/Y invader_2_coord_y[1] gnd Gnd nfet w=20 l=2
+  ad=100p pd=50u as=0 ps=0
M6503 INVX2_31/Y invader_2_coord_y[1] vdd vdd pfet w=40 l=2
+  ad=0.2n pd=90u as=0 ps=0
M6504 INVX2_53/Y INVX2_53/A gnd Gnd nfet w=20 l=2
+  ad=100p pd=50u as=0 ps=0
M6505 INVX2_53/Y INVX2_53/A vdd vdd pfet w=40 l=2
+  ad=0.2n pd=90u as=0 ps=0
M6506 INVX2_64/Y invader_1_coord_x[2] gnd Gnd nfet w=20 l=2
+  ad=100p pd=50u as=0 ps=0
M6507 INVX2_64/Y invader_1_coord_x[2] vdd vdd pfet w=40 l=2
+  ad=0.2n pd=90u as=0 ps=0
M6508 INVX2_86/Y shield_hp[1] gnd Gnd nfet w=20 l=2
+  ad=100p pd=50u as=0 ps=0
M6509 INVX2_86/Y shield_hp[1] vdd vdd pfet w=40 l=2
+  ad=0.2n pd=90u as=0 ps=0
M6510 INVX2_97/Y INVX2_97/A gnd Gnd nfet w=20 l=2
+  ad=100p pd=50u as=0 ps=0
M6511 INVX2_97/Y INVX2_97/A vdd vdd pfet w=40 l=2
+  ad=0.2n pd=90u as=0 ps=0
M6512 INVX2_75/Y INVX2_75/A gnd Gnd nfet w=20 l=2
+  ad=100p pd=50u as=0 ps=0
M6513 INVX2_75/Y INVX2_75/A vdd vdd pfet w=40 l=2
+  ad=0.2n pd=90u as=0 ps=0
M6514 gnd player_bullet_coord_x[3] OAI21X1_16/a_2_6# Gnd nfet w=20 l=2
+  ad=0 pd=0 as=0.22n ps=0.102m
M6515 vdd NAND3X1_5/Y INVX2_67/A vdd pfet w=20 l=2
+  ad=0 pd=0 as=0.22n ps=92u
M6516 INVX2_67/A NAND3X1_5/Y OAI21X1_16/a_2_6# Gnd nfet w=20 l=2
+  ad=100p pd=50u as=0 ps=0
M6517 INVX2_67/A INVX2_66/Y OAI21X1_16/a_9_54# vdd pfet w=40 l=2
+  ad=0 pd=0 as=0.12n ps=86u
M6518 OAI21X1_16/a_9_54# player_bullet_coord_x[3] vdd vdd pfet w=40 l=2
+  ad=0 pd=0 as=0 ps=0
M6519 OAI21X1_16/a_2_6# INVX2_66/Y gnd Gnd nfet w=20 l=2
+  ad=0 pd=0 as=0 ps=0
M6520 gnd INVX2_14/Y OAI21X1_49/a_2_6# Gnd nfet w=20 l=2
+  ad=0 pd=0 as=0.22n ps=0.102m
M6521 vdd NAND2X1_1/B INVX2_139/A vdd pfet w=20 l=2
+  ad=0 pd=0 as=0.22n ps=92u
M6522 INVX2_139/A NAND2X1_1/B OAI21X1_49/a_2_6# Gnd nfet w=20 l=2
+  ad=100p pd=50u as=0 ps=0
M6523 INVX2_139/A OAI21X1_49/B OAI21X1_49/a_9_54# vdd pfet w=40 l=2
+  ad=0 pd=0 as=0.12n ps=86u
M6524 OAI21X1_49/a_9_54# INVX2_14/Y vdd vdd pfet w=40 l=2
+  ad=0 pd=0 as=0 ps=0
M6525 OAI21X1_49/a_2_6# OAI21X1_49/B gnd Gnd nfet w=20 l=2
+  ad=0 pd=0 as=0 ps=0
M6526 gnd NOR2X1_17/Y OAI21X1_38/a_2_6# Gnd nfet w=20 l=2
+  ad=0 pd=0 as=0.22n ps=0.102m
M6527 vdd NAND2X1_9/Y AOI21X1_0/B vdd pfet w=20 l=2
+  ad=0 pd=0 as=0.22n ps=92u
M6528 AOI21X1_0/B NAND2X1_9/Y OAI21X1_38/a_2_6# Gnd nfet w=20 l=2
+  ad=100p pd=50u as=0 ps=0
M6529 AOI21X1_0/B INVX2_12/Y OAI21X1_38/a_9_54# vdd pfet w=40 l=2
+  ad=0 pd=0 as=0.12n ps=86u
M6530 OAI21X1_38/a_9_54# NOR2X1_17/Y vdd vdd pfet w=40 l=2
+  ad=0 pd=0 as=0 ps=0
M6531 OAI21X1_38/a_2_6# INVX2_12/Y gnd Gnd nfet w=20 l=2
+  ad=0 pd=0 as=0 ps=0
M6532 gnd INVX2_79/Y OAI21X1_27/a_2_6# Gnd nfet w=20 l=2
+  ad=0 pd=0 as=0.22n ps=0.102m
M6533 vdd NAND3X1_8/Y INVX2_80/A vdd pfet w=20 l=2
+  ad=0 pd=0 as=0.22n ps=92u
M6534 INVX2_80/A NAND3X1_8/Y OAI21X1_27/a_2_6# Gnd nfet w=20 l=2
+  ad=100p pd=50u as=0 ps=0
M6535 INVX2_80/A INVX2_23/Y OAI21X1_27/a_9_54# vdd pfet w=40 l=2
+  ad=0 pd=0 as=0.12n ps=86u
M6536 OAI21X1_27/a_9_54# INVX2_79/Y vdd vdd pfet w=40 l=2
+  ad=0 pd=0 as=0 ps=0
M6537 OAI21X1_27/a_2_6# INVX2_23/Y gnd Gnd nfet w=20 l=2
+  ad=0 pd=0 as=0 ps=0
M6538 AND2X2_19/a_2_6# XNOR2X1_3/Y vdd vdd pfet w=20 l=2
+  ad=0.12n pd=52u as=0 ps=0
M6539 AND2X2_19/a_9_6# XNOR2X1_3/Y AND2X2_19/a_2_6# Gnd nfet w=20 l=2
+  ad=59.999996p pd=46u as=100p ps=50u
M6540 AND2X2_19/Y AND2X2_19/a_2_6# gnd Gnd nfet w=20 l=2
+  ad=100p pd=50u as=0 ps=0
M6541 AND2X2_19/Y AND2X2_19/a_2_6# vdd vdd pfet w=40 l=2
+  ad=0.2n pd=90u as=0 ps=0
M6542 vdd NAND2X1_1/B AND2X2_19/a_2_6# vdd pfet w=20 l=2
+  ad=0 pd=0 as=0 ps=0
M6543 gnd NAND2X1_1/B AND2X2_19/a_9_6# Gnd nfet w=20 l=2
+  ad=0 pd=0 as=0 ps=0
M6544 gnd INVX2_98/Y XNOR2X1_3/a_2_6# Gnd nfet w=20 l=2
+  ad=0 pd=0 as=100p ps=50u
M6545 XNOR2X1_3/Y INVX2_98/Y XNOR2X1_3/a_18_6# Gnd nfet w=20 l=2
+  ad=0.2n pd=60u as=59.999996p ps=46u
M6546 XNOR2X1_3/a_12_41# INVX2_95/A gnd Gnd nfet w=20 l=2
+  ad=100p pd=50u as=0 ps=0
M6547 XNOR2X1_3/a_18_54# XNOR2X1_3/a_12_41# vdd vdd pfet w=40 l=2
+  ad=0.12n pd=86u as=0 ps=0
M6548 XNOR2X1_3/a_35_6# XNOR2X1_3/a_2_6# XNOR2X1_3/Y Gnd nfet w=20 l=2
+  ad=59.999996p pd=46u as=0 ps=0
M6549 XNOR2X1_3/a_18_6# XNOR2X1_3/a_12_41# gnd Gnd nfet w=20 l=2
+  ad=0 pd=0 as=0 ps=0
M6550 vdd INVX2_98/Y XNOR2X1_3/a_2_6# vdd pfet w=40 l=2
+  ad=0 pd=0 as=0.2n ps=90u
M6551 vdd INVX2_95/A XNOR2X1_3/a_35_54# vdd pfet w=40 l=2
+  ad=0 pd=0 as=0.12n ps=86u
M6552 XNOR2X1_3/Y XNOR2X1_3/a_2_6# XNOR2X1_3/a_18_54# vdd pfet w=40 l=2
+  ad=0.4n pd=100u as=0 ps=0
M6553 XNOR2X1_3/a_35_54# INVX2_98/Y XNOR2X1_3/Y vdd pfet w=40 l=2
+  ad=0 pd=0 as=0 ps=0
M6554 XNOR2X1_3/a_12_41# INVX2_95/A vdd vdd pfet w=40 l=2
+  ad=0.2n pd=90u as=0 ps=0
M6555 gnd INVX2_95/A XNOR2X1_3/a_35_6# Gnd nfet w=20 l=2
+  ad=0 pd=0 as=0 ps=0
M6556 DFFNEGX1_60/a_76_6# BUFX2_3/Y DFFNEGX1_60/a_66_6# Gnd nfet w=10 l=2
+  ad=29.999998p pd=26u as=80p ps=36u
M6557 gnd BUFX2_3/Y DFFNEGX1_60/a_2_6# Gnd nfet w=20 l=2
+  ad=0 pd=0 as=100p ps=50u
M6558 DFFNEGX1_60/a_66_6# DFFNEGX1_60/a_2_6# DFFNEGX1_60/a_61_6# Gnd nfet w=10 l=2
+  ad=0 pd=0 as=29.999998p ps=26u
M6559 shield_coord_y[2] DFFNEGX1_60/a_66_6# gnd Gnd nfet w=20 l=2
+  ad=100p pd=50u as=0 ps=0
M6560 DFFNEGX1_60/a_23_6# BUFX2_3/Y DFFNEGX1_60/a_17_6# Gnd nfet w=10 l=2
+  ad=59.999996p pd=32u as=40p ps=28u
M6561 DFFNEGX1_60/a_23_6# DFFNEGX1_60/a_2_6# DFFNEGX1_60/a_17_74# vdd pfet w=20 l=2
+  ad=0.12n pd=52u as=80p ps=48u
M6562 gnd DFFNEGX1_60/a_34_4# DFFNEGX1_60/a_31_6# Gnd nfet w=10 l=2
+  ad=0 pd=0 as=29.999998p ps=26u
M6563 vdd DFFNEGX1_60/a_34_4# DFFNEGX1_60/a_31_74# vdd pfet w=20 l=2
+  ad=0 pd=0 as=80p ps=48u
M6564 DFFNEGX1_60/a_61_74# DFFNEGX1_60/a_34_4# vdd vdd pfet w=20 l=2
+  ad=59.999996p pd=46u as=0 ps=0
M6565 DFFNEGX1_60/a_34_4# DFFNEGX1_60/a_23_6# vdd vdd pfet w=20 l=2
+  ad=100p pd=50u as=0 ps=0
M6566 DFFNEGX1_60/a_34_4# DFFNEGX1_60/a_23_6# gnd Gnd nfet w=10 l=2
+  ad=50p pd=30u as=0 ps=0
M6567 vdd shield_coord_y[2] DFFNEGX1_60/a_76_84# vdd pfet w=10 l=2
+  ad=0 pd=0 as=29.999998p ps=26u
M6568 gnd shield_coord_y[2] DFFNEGX1_60/a_76_6# Gnd nfet w=10 l=2
+  ad=0 pd=0 as=0 ps=0
M6569 DFFNEGX1_60/a_61_6# DFFNEGX1_60/a_34_4# gnd Gnd nfet w=10 l=2
+  ad=0 pd=0 as=0 ps=0
M6570 DFFNEGX1_60/a_76_84# DFFNEGX1_60/a_2_6# DFFNEGX1_60/a_66_6# vdd pfet w=10 l=2
+  ad=0 pd=0 as=0.15n ps=56u
M6571 shield_coord_y[2] DFFNEGX1_60/a_66_6# vdd vdd pfet w=40 l=2
+  ad=0.2n pd=90u as=0 ps=0
M6572 vdd BUFX2_3/Y DFFNEGX1_60/a_2_6# vdd pfet w=40 l=2
+  ad=0 pd=0 as=0.2n ps=90u
M6573 DFFNEGX1_60/a_31_6# DFFNEGX1_60/a_2_6# DFFNEGX1_60/a_23_6# Gnd nfet w=10 l=2
+  ad=0 pd=0 as=0 ps=0
M6574 DFFNEGX1_60/a_66_6# BUFX2_3/Y DFFNEGX1_60/a_61_74# vdd pfet w=20 l=2
+  ad=0 pd=0 as=0 ps=0
M6575 DFFNEGX1_60/a_17_74# OAI21X1_97/Y vdd vdd pfet w=20 l=2
+  ad=0 pd=0 as=0 ps=0
M6576 DFFNEGX1_60/a_31_74# BUFX2_3/Y DFFNEGX1_60/a_23_6# vdd pfet w=20 l=2
+  ad=0 pd=0 as=0 ps=0
M6577 DFFNEGX1_60/a_17_6# OAI21X1_97/Y gnd Gnd nfet w=10 l=2
+  ad=0 pd=0 as=0 ps=0
M6578 DFFNEGX1_71/a_76_6# BUFX2_3/Y DFFNEGX1_71/a_66_6# Gnd nfet w=10 l=2
+  ad=29.999998p pd=26u as=80p ps=36u
M6579 gnd BUFX2_3/Y DFFNEGX1_71/a_2_6# Gnd nfet w=20 l=2
+  ad=0 pd=0 as=100p ps=50u
M6580 DFFNEGX1_71/a_66_6# DFFNEGX1_71/a_2_6# DFFNEGX1_71/a_61_6# Gnd nfet w=10 l=2
+  ad=0 pd=0 as=29.999998p ps=26u
M6581 player_coord_x[0] DFFNEGX1_71/a_66_6# gnd Gnd nfet w=20 l=2
+  ad=100p pd=50u as=0 ps=0
M6582 DFFNEGX1_71/a_23_6# BUFX2_3/Y DFFNEGX1_71/a_17_6# Gnd nfet w=10 l=2
+  ad=59.999996p pd=32u as=40p ps=28u
M6583 DFFNEGX1_71/a_23_6# DFFNEGX1_71/a_2_6# DFFNEGX1_71/a_17_74# vdd pfet w=20 l=2
+  ad=0.12n pd=52u as=80p ps=48u
M6584 gnd DFFNEGX1_71/a_34_4# DFFNEGX1_71/a_31_6# Gnd nfet w=10 l=2
+  ad=0 pd=0 as=29.999998p ps=26u
M6585 vdd DFFNEGX1_71/a_34_4# DFFNEGX1_71/a_31_74# vdd pfet w=20 l=2
+  ad=0 pd=0 as=80p ps=48u
M6586 DFFNEGX1_71/a_61_74# DFFNEGX1_71/a_34_4# vdd vdd pfet w=20 l=2
+  ad=59.999996p pd=46u as=0 ps=0
M6587 DFFNEGX1_71/a_34_4# DFFNEGX1_71/a_23_6# vdd vdd pfet w=20 l=2
+  ad=100p pd=50u as=0 ps=0
M6588 DFFNEGX1_71/a_34_4# DFFNEGX1_71/a_23_6# gnd Gnd nfet w=10 l=2
+  ad=50p pd=30u as=0 ps=0
M6589 vdd player_coord_x[0] DFFNEGX1_71/a_76_84# vdd pfet w=10 l=2
+  ad=0 pd=0 as=29.999998p ps=26u
M6590 gnd player_coord_x[0] DFFNEGX1_71/a_76_6# Gnd nfet w=10 l=2
+  ad=0 pd=0 as=0 ps=0
M6591 DFFNEGX1_71/a_61_6# DFFNEGX1_71/a_34_4# gnd Gnd nfet w=10 l=2
+  ad=0 pd=0 as=0 ps=0
M6592 DFFNEGX1_71/a_76_84# DFFNEGX1_71/a_2_6# DFFNEGX1_71/a_66_6# vdd pfet w=10 l=2
+  ad=0 pd=0 as=0.15n ps=56u
M6593 player_coord_x[0] DFFNEGX1_71/a_66_6# vdd vdd pfet w=40 l=2
+  ad=0.2n pd=90u as=0 ps=0
M6594 vdd BUFX2_3/Y DFFNEGX1_71/a_2_6# vdd pfet w=40 l=2
+  ad=0 pd=0 as=0.2n ps=90u
M6595 DFFNEGX1_71/a_31_6# DFFNEGX1_71/a_2_6# DFFNEGX1_71/a_23_6# Gnd nfet w=10 l=2
+  ad=0 pd=0 as=0 ps=0
M6596 DFFNEGX1_71/a_66_6# BUFX2_3/Y DFFNEGX1_71/a_61_74# vdd pfet w=20 l=2
+  ad=0 pd=0 as=0 ps=0
M6597 DFFNEGX1_71/a_17_74# NAND2X1_53/Y vdd vdd pfet w=20 l=2
+  ad=0 pd=0 as=0 ps=0
M6598 DFFNEGX1_71/a_31_74# BUFX2_3/Y DFFNEGX1_71/a_23_6# vdd pfet w=20 l=2
+  ad=0 pd=0 as=0 ps=0
M6599 DFFNEGX1_71/a_17_6# NAND2X1_53/Y gnd Gnd nfet w=10 l=2
+  ad=0 pd=0 as=0 ps=0
M6600 DFFNEGX1_82/a_76_6# BUFX2_2/Y DFFNEGX1_82/a_66_6# Gnd nfet w=10 l=2
+  ad=29.999998p pd=26u as=80p ps=36u
M6601 gnd BUFX2_2/Y DFFNEGX1_82/a_2_6# Gnd nfet w=20 l=2
+  ad=0 pd=0 as=100p ps=50u
M6602 DFFNEGX1_82/a_66_6# DFFNEGX1_82/a_2_6# DFFNEGX1_82/a_61_6# Gnd nfet w=10 l=2
+  ad=0 pd=0 as=29.999998p ps=26u
M6603 INVX2_150/A DFFNEGX1_82/a_66_6# gnd Gnd nfet w=20 l=2
+  ad=100p pd=50u as=0 ps=0
M6604 DFFNEGX1_82/a_23_6# BUFX2_2/Y DFFNEGX1_82/a_17_6# Gnd nfet w=10 l=2
+  ad=59.999996p pd=32u as=40p ps=28u
M6605 DFFNEGX1_82/a_23_6# DFFNEGX1_82/a_2_6# DFFNEGX1_82/a_17_74# vdd pfet w=20 l=2
+  ad=0.12n pd=52u as=80p ps=48u
M6606 gnd DFFNEGX1_82/a_34_4# DFFNEGX1_82/a_31_6# Gnd nfet w=10 l=2
+  ad=0 pd=0 as=29.999998p ps=26u
M6607 vdd DFFNEGX1_82/a_34_4# DFFNEGX1_82/a_31_74# vdd pfet w=20 l=2
+  ad=0 pd=0 as=80p ps=48u
M6608 DFFNEGX1_82/a_61_74# DFFNEGX1_82/a_34_4# vdd vdd pfet w=20 l=2
+  ad=59.999996p pd=46u as=0 ps=0
M6609 DFFNEGX1_82/a_34_4# DFFNEGX1_82/a_23_6# vdd vdd pfet w=20 l=2
+  ad=100p pd=50u as=0 ps=0
M6610 DFFNEGX1_82/a_34_4# DFFNEGX1_82/a_23_6# gnd Gnd nfet w=10 l=2
+  ad=50p pd=30u as=0 ps=0
M6611 vdd INVX2_150/A DFFNEGX1_82/a_76_84# vdd pfet w=10 l=2
+  ad=0 pd=0 as=29.999998p ps=26u
M6612 gnd INVX2_150/A DFFNEGX1_82/a_76_6# Gnd nfet w=10 l=2
+  ad=0 pd=0 as=0 ps=0
M6613 DFFNEGX1_82/a_61_6# DFFNEGX1_82/a_34_4# gnd Gnd nfet w=10 l=2
+  ad=0 pd=0 as=0 ps=0
M6614 DFFNEGX1_82/a_76_84# DFFNEGX1_82/a_2_6# DFFNEGX1_82/a_66_6# vdd pfet w=10 l=2
+  ad=0 pd=0 as=0.15n ps=56u
M6615 INVX2_150/A DFFNEGX1_82/a_66_6# vdd vdd pfet w=40 l=2
+  ad=0.2n pd=90u as=0 ps=0
M6616 vdd BUFX2_2/Y DFFNEGX1_82/a_2_6# vdd pfet w=40 l=2
+  ad=0 pd=0 as=0.2n ps=90u
M6617 DFFNEGX1_82/a_31_6# DFFNEGX1_82/a_2_6# DFFNEGX1_82/a_23_6# Gnd nfet w=10 l=2
+  ad=0 pd=0 as=0 ps=0
M6618 DFFNEGX1_82/a_66_6# BUFX2_2/Y DFFNEGX1_82/a_61_74# vdd pfet w=20 l=2
+  ad=0 pd=0 as=0 ps=0
M6619 DFFNEGX1_82/a_17_74# NOR2X1_59/Y vdd vdd pfet w=20 l=2
+  ad=0 pd=0 as=0 ps=0
M6620 DFFNEGX1_82/a_31_74# BUFX2_2/Y DFFNEGX1_82/a_23_6# vdd pfet w=20 l=2
+  ad=0 pd=0 as=0 ps=0
M6621 DFFNEGX1_82/a_17_6# NOR2X1_59/Y gnd Gnd nfet w=10 l=2
+  ad=0 pd=0 as=0 ps=0
M6622 vdd invader_1_coord_y[2] HAX1_7/a_2_74# vdd pfet w=20 l=2
+  ad=0 pd=0 as=0.2n ps=100u
M6623 HAX1_7/a_41_74# HAX1_7/a_2_74# vdd vdd pfet w=20 l=2
+  ad=0.22n pd=92u as=0 ps=0
M6624 HAX1_7/a_9_6# invader_1_coord_y[2] gnd Gnd nfet w=20 l=2
+  ad=59.999996p pd=46u as=0 ps=0
M6625 HAX1_7/a_41_74# HAX1_7/B HAX1_7/a_38_6# Gnd nfet w=20 l=2
+  ad=0.12n pd=52u as=0.216n ps=0.102m
M6626 vdd invader_1_coord_y[2] HAX1_7/a_49_54# vdd pfet w=40 l=2
+  ad=0 pd=0 as=0.12n ps=86u
M6627 vdd HAX1_7/a_2_74# HAX1_6/B vdd pfet w=20 l=2
+  ad=0 pd=0 as=100p ps=50u
M6628 HAX1_7/a_38_6# HAX1_7/a_2_74# gnd Gnd nfet w=20 l=2
+  ad=0 pd=0 as=0 ps=0
M6629 HAX1_7/YS HAX1_7/a_41_74# vdd vdd pfet w=20 l=2
+  ad=100p pd=50u as=0 ps=0
M6630 HAX1_7/a_38_6# invader_1_coord_y[2] HAX1_7/a_41_74# Gnd nfet w=20 l=2
+  ad=0 pd=0 as=0 ps=0
M6631 HAX1_7/YS HAX1_7/a_41_74# gnd Gnd nfet w=10 l=2
+  ad=50p pd=30u as=0 ps=0
M6632 HAX1_7/a_2_74# HAX1_7/B vdd vdd pfet w=20 l=2
+  ad=0 pd=0 as=0 ps=0
M6633 HAX1_7/a_2_74# HAX1_7/B HAX1_7/a_9_6# Gnd nfet w=20 l=2
+  ad=100p pd=50u as=0 ps=0
M6634 HAX1_7/a_49_54# HAX1_7/B HAX1_7/a_41_74# vdd pfet w=40 l=2
+  ad=0 pd=0 as=0 ps=0
M6635 gnd HAX1_7/a_2_74# HAX1_6/B Gnd nfet w=10 l=2
+  ad=0 pd=0 as=50p ps=30u
M6636 AND2X2_3/a_2_6# player_bullet_coord_x[1] vdd vdd pfet w=20 l=2
+  ad=0.12n pd=52u as=0 ps=0
M6637 AND2X2_3/a_9_6# player_bullet_coord_x[1] AND2X2_3/a_2_6# Gnd nfet w=20 l=2
+  ad=59.999996p pd=46u as=100p ps=50u
M6638 XOR2X1_0/A AND2X2_3/a_2_6# gnd Gnd nfet w=20 l=2
+  ad=100p pd=50u as=0 ps=0
M6639 XOR2X1_0/A AND2X2_3/a_2_6# vdd vdd pfet w=40 l=2
+  ad=0.2n pd=90u as=0 ps=0
M6640 vdd player_bullet_coord_x[2] AND2X2_3/a_2_6# vdd pfet w=20 l=2
+  ad=0 pd=0 as=0 ps=0
M6641 gnd player_bullet_coord_x[2] AND2X2_3/a_9_6# Gnd nfet w=20 l=2
+  ad=0 pd=0 as=0 ps=0
M6642 NAND3X1_19/Y INVX2_31/Y vdd vdd pfet w=20 l=2
+  ad=0.22n pd=0.102m as=0 ps=0
M6643 NAND3X1_19/a_9_6# INVX2_31/Y gnd Gnd nfet w=30 l=2
+  ad=90p pd=66u as=0 ps=0
M6644 NAND3X1_19/Y INVX2_147/Y vdd vdd pfet w=20 l=2
+  ad=0 pd=0 as=0 ps=0
M6645 NAND3X1_19/Y INVX2_147/Y NAND3X1_19/a_14_6# Gnd nfet w=30 l=2
+  ad=0.15n pd=70u as=90p ps=66u
M6646 vdd INVX2_38/Y NAND3X1_19/Y vdd pfet w=20 l=2
+  ad=0 pd=0 as=0 ps=0
M6647 NAND3X1_19/a_14_6# INVX2_38/Y NAND3X1_19/a_9_6# Gnd nfet w=30 l=2
+  ad=0 pd=0 as=0 ps=0
M6648 NOR2X1_19/Y NOR2X1_19/A gnd Gnd nfet w=10 l=2
+  ad=59.999996p pd=32u as=0 ps=0
M6649 NOR2X1_19/Y OR2X1_15/A NOR2X1_19/a_9_54# vdd pfet w=40 l=2
+  ad=0.2n pd=90u as=0.12n ps=86u
M6650 NOR2X1_19/a_9_54# NOR2X1_19/A vdd vdd pfet w=40 l=2
+  ad=0 pd=0 as=0 ps=0
M6651 gnd OR2X1_15/A NOR2X1_19/Y Gnd nfet w=10 l=2
+  ad=0 pd=0 as=0 ps=0
M6652 NAND2X1_30/Y XOR2X1_5/A vdd vdd pfet w=20 l=2
+  ad=0.12n pd=52u as=0 ps=0
M6653 NAND2X1_30/a_9_6# XOR2X1_5/A gnd Gnd nfet w=20 l=2
+  ad=59.999996p pd=46u as=0 ps=0
M6654 vdd invader_1_coord_x[3] NAND2X1_30/Y vdd pfet w=20 l=2
+  ad=0 pd=0 as=0 ps=0
M6655 NAND2X1_30/Y invader_1_coord_x[3] NAND2X1_30/a_9_6# Gnd nfet w=20 l=2
+  ad=100p pd=50u as=0 ps=0
M6656 NAND2X1_52/Y NAND2X1_52/A vdd vdd pfet w=20 l=2
+  ad=0.12n pd=52u as=0 ps=0
M6657 NAND2X1_52/a_9_6# NAND2X1_52/A gnd Gnd nfet w=20 l=2
+  ad=59.999996p pd=46u as=0 ps=0
M6658 vdd AND2X2_19/Y NAND2X1_52/Y vdd pfet w=20 l=2
+  ad=0 pd=0 as=0 ps=0
M6659 NAND2X1_52/Y AND2X2_19/Y NAND2X1_52/a_9_6# Gnd nfet w=20 l=2
+  ad=100p pd=50u as=0 ps=0
M6660 OAI22X1_5/B INVX2_136/Y vdd vdd pfet w=20 l=2
+  ad=0.12n pd=52u as=0 ps=0
M6661 NAND2X1_41/a_9_6# INVX2_136/Y gnd Gnd nfet w=20 l=2
+  ad=59.999996p pd=46u as=0 ps=0
M6662 vdd INVX2_59/Y OAI22X1_5/B vdd pfet w=20 l=2
+  ad=0 pd=0 as=0 ps=0
M6663 OAI22X1_5/B INVX2_59/Y NAND2X1_41/a_9_6# Gnd nfet w=20 l=2
+  ad=100p pd=50u as=0 ps=0
M6664 NOR2X1_55/B INVX2_151/Y vdd vdd pfet w=20 l=2
+  ad=0.12n pd=52u as=0 ps=0
M6665 NAND2X1_63/a_9_6# INVX2_151/Y gnd Gnd nfet w=20 l=2
+  ad=59.999996p pd=46u as=0 ps=0
M6666 vdd INVX2_165/Y NOR2X1_55/B vdd pfet w=20 l=2
+  ad=0 pd=0 as=0 ps=0
M6667 NOR2X1_55/B INVX2_165/Y NAND2X1_63/a_9_6# Gnd nfet w=20 l=2
+  ad=100p pd=50u as=0 ps=0
M6668 NAND2X1_74/Y player_coord_x[2] vdd vdd pfet w=20 l=2
+  ad=0.12n pd=52u as=0 ps=0
M6669 NAND2X1_74/a_9_6# player_coord_x[2] gnd Gnd nfet w=20 l=2
+  ad=59.999996p pd=46u as=0 ps=0
M6670 vdd INVX2_44/Y NAND2X1_74/Y vdd pfet w=20 l=2
+  ad=0 pd=0 as=0 ps=0
M6671 NAND2X1_74/Y INVX2_44/Y NAND2X1_74/a_9_6# Gnd nfet w=20 l=2
+  ad=100p pd=50u as=0 ps=0
M6672 gnd INVX2_83/Y AOI22X1_50/a_28_6# Gnd nfet w=20 l=2
+  ad=0 pd=0 as=59.999996p ps=46u
M6673 INVX2_172/A INVX2_126/A AOI22X1_50/a_11_6# Gnd nfet w=20 l=2
+  ad=0.2n pd=60u as=59.999996p ps=46u
M6674 AOI22X1_50/a_11_6# NOR2X1_54/Y gnd Gnd nfet w=20 l=2
+  ad=0 pd=0 as=0 ps=0
M6675 AOI22X1_50/a_2_54# INVX2_126/A vdd vdd pfet w=40 l=2
+  ad=0.64n pd=0.272m as=0 ps=0
M6676 AOI22X1_50/a_28_6# INVX2_168/Y INVX2_172/A Gnd nfet w=20 l=2
+  ad=0 pd=0 as=0 ps=0
M6677 vdd NOR2X1_54/Y AOI22X1_50/a_2_54# vdd pfet w=40 l=2
+  ad=0 pd=0 as=0 ps=0
M6678 INVX2_172/A INVX2_168/Y AOI22X1_50/a_2_54# vdd pfet w=40 l=2
+  ad=0.24n pd=92u as=0 ps=0
M6679 AOI22X1_50/a_2_54# INVX2_83/Y INVX2_172/A vdd pfet w=40 l=2
+  ad=0 pd=0 as=0 ps=0
M6680 gnd invader_2_coord_x[2] AOI22X1_61/a_28_6# Gnd nfet w=20 l=2
+  ad=0 pd=0 as=59.999996p ps=46u
M6681 NOR2X1_56/A NAND2X1_74/Y AOI22X1_61/a_11_6# Gnd nfet w=20 l=2
+  ad=0.2n pd=60u as=59.999996p ps=46u
M6682 AOI22X1_61/a_11_6# XNOR2X1_6/A gnd Gnd nfet w=20 l=2
+  ad=0 pd=0 as=0 ps=0
M6683 AOI22X1_61/a_2_54# NAND2X1_74/Y vdd vdd pfet w=40 l=2
+  ad=0.64n pd=0.272m as=0 ps=0
M6684 AOI22X1_61/a_28_6# INVX2_175/Y NOR2X1_56/A Gnd nfet w=20 l=2
+  ad=0 pd=0 as=0 ps=0
M6685 vdd XNOR2X1_6/A AOI22X1_61/a_2_54# vdd pfet w=40 l=2
+  ad=0 pd=0 as=0 ps=0
M6686 NOR2X1_56/A INVX2_175/Y AOI22X1_61/a_2_54# vdd pfet w=40 l=2
+  ad=0.24n pd=92u as=0 ps=0
M6687 AOI22X1_61/a_2_54# invader_2_coord_x[2] NOR2X1_56/A vdd pfet w=40 l=2
+  ad=0 pd=0 as=0 ps=0
M6688 gnd player_bullet_coord_y[1] OAI22X1_1/a_2_6# Gnd nfet w=20 l=2
+  ad=0 pd=0 as=0.32n ps=0.152m
M6689 OAI22X1_1/a_2_6# player_bullet_coord_y[0] OAI22X1_1/Y Gnd nfet w=20 l=2
+  ad=0 pd=0 as=0.12n ps=52u
M6690 OAI22X1_1/Y invader_2_coord_y[0] OAI22X1_1/a_2_6# Gnd nfet w=20 l=2
+  ad=0 pd=0 as=0 ps=0
M6691 OAI22X1_1/Y INVX2_35/A OAI22X1_1/a_9_54# vdd pfet w=40 l=2
+  ad=0.48n pd=0.104m as=0.12n ps=86u
M6692 OAI22X1_1/a_28_54# invader_2_coord_y[0] OAI22X1_1/Y vdd pfet w=40 l=2
+  ad=0.12n pd=86u as=0 ps=0
M6693 OAI22X1_1/a_9_54# player_bullet_coord_y[1] vdd vdd pfet w=40 l=2
+  ad=0 pd=0 as=0 ps=0
M6694 OAI22X1_1/a_2_6# INVX2_35/A gnd Gnd nfet w=20 l=2
+  ad=0 pd=0 as=0 ps=0
M6695 vdd player_bullet_coord_y[0] OAI22X1_1/a_28_54# vdd pfet w=40 l=2
+  ad=0 pd=0 as=0 ps=0
M6696 INVX2_10/Y INVX2_10/A gnd Gnd nfet w=20 l=2
+  ad=100p pd=50u as=0 ps=0
M6697 INVX2_10/Y INVX2_10/A vdd vdd pfet w=40 l=2
+  ad=0.2n pd=90u as=0 ps=0
M6698 INVX2_21/Y player_bullet_coord_x[0] gnd Gnd nfet w=20 l=2
+  ad=100p pd=50u as=0 ps=0
M6699 INVX2_21/Y player_bullet_coord_x[0] vdd vdd pfet w=40 l=2
+  ad=0.2n pd=90u as=0 ps=0
M6700 INVX2_43/Y NOR2X1_7/Y gnd Gnd nfet w=20 l=2
+  ad=100p pd=50u as=0 ps=0
M6701 INVX2_43/Y NOR2X1_7/Y vdd vdd pfet w=40 l=2
+  ad=0.2n pd=90u as=0 ps=0
M6702 INVX2_32/Y INVX2_32/A gnd Gnd nfet w=20 l=2
+  ad=100p pd=50u as=0 ps=0
M6703 INVX2_32/Y INVX2_32/A vdd vdd pfet w=40 l=2
+  ad=0.2n pd=90u as=0 ps=0
M6704 INVX2_54/Y INVX2_54/A gnd Gnd nfet w=20 l=2
+  ad=100p pd=50u as=0 ps=0
M6705 INVX2_54/Y INVX2_54/A vdd vdd pfet w=40 l=2
+  ad=0.2n pd=90u as=0 ps=0
M6706 INVX2_87/Y INVX2_87/A gnd Gnd nfet w=20 l=2
+  ad=100p pd=50u as=0 ps=0
M6707 INVX2_87/Y INVX2_87/A vdd vdd pfet w=40 l=2
+  ad=0.2n pd=90u as=0 ps=0
M6708 INVX2_76/Y invader_1_coord_y[3] gnd Gnd nfet w=20 l=2
+  ad=100p pd=50u as=0 ps=0
M6709 INVX2_76/Y invader_1_coord_y[3] vdd vdd pfet w=40 l=2
+  ad=0.2n pd=90u as=0 ps=0
M6710 INVX2_65/Y INVX2_65/A gnd Gnd nfet w=20 l=2
+  ad=100p pd=50u as=0 ps=0
M6711 INVX2_65/Y INVX2_65/A vdd vdd pfet w=40 l=2
+  ad=0.2n pd=90u as=0 ps=0
M6712 INVX2_98/Y INVX2_98/A gnd Gnd nfet w=20 l=2
+  ad=100p pd=50u as=0 ps=0
M6713 INVX2_98/Y INVX2_98/A vdd vdd pfet w=40 l=2
+  ad=0.2n pd=90u as=0 ps=0
M6714 gnd INVX2_69/A OAI21X1_17/a_2_6# Gnd nfet w=20 l=2
+  ad=0 pd=0 as=0.22n ps=0.102m
M6715 vdd INVX2_70/Y OAI21X1_17/Y vdd pfet w=20 l=2
+  ad=0 pd=0 as=0.22n ps=92u
M6716 OAI21X1_17/Y INVX2_70/Y OAI21X1_17/a_2_6# Gnd nfet w=20 l=2
+  ad=100p pd=50u as=0 ps=0
M6717 OAI21X1_17/Y OAI21X1_18/Y OAI21X1_17/a_9_54# vdd pfet w=40 l=2
+  ad=0 pd=0 as=0.12n ps=86u
M6718 OAI21X1_17/a_9_54# INVX2_69/A vdd vdd pfet w=40 l=2
+  ad=0 pd=0 as=0 ps=0
M6719 OAI21X1_17/a_2_6# OAI21X1_18/Y gnd Gnd nfet w=20 l=2
+  ad=0 pd=0 as=0 ps=0
M6720 gnd invader_bullet_coord_x[3] OAI21X1_28/a_2_6# Gnd nfet w=20 l=2
+  ad=0 pd=0 as=0.22n ps=0.102m
M6721 vdd OAI21X1_29/Y OAI21X1_28/Y vdd pfet w=20 l=2
+  ad=0 pd=0 as=0.22n ps=92u
M6722 OAI21X1_28/Y OAI21X1_29/Y OAI21X1_28/a_2_6# Gnd nfet w=20 l=2
+  ad=100p pd=50u as=0 ps=0
M6723 OAI21X1_28/Y INVX2_173/A OAI21X1_28/a_9_54# vdd pfet w=40 l=2
+  ad=0 pd=0 as=0.12n ps=86u
M6724 OAI21X1_28/a_9_54# invader_bullet_coord_x[3] vdd vdd pfet w=40 l=2
+  ad=0 pd=0 as=0 ps=0
M6725 OAI21X1_28/a_2_6# INVX2_173/A gnd Gnd nfet w=20 l=2
+  ad=0 pd=0 as=0 ps=0
M6726 gnd INVX2_2/A OAI21X1_39/a_2_6# Gnd nfet w=20 l=2
+  ad=0 pd=0 as=0.22n ps=0.102m
M6727 vdd NAND2X1_1/B AOI21X1_0/C vdd pfet w=20 l=2
+  ad=0 pd=0 as=0.22n ps=92u
M6728 AOI21X1_0/C NAND2X1_1/B OAI21X1_39/a_2_6# Gnd nfet w=20 l=2
+  ad=100p pd=50u as=0 ps=0
M6729 AOI21X1_0/C OAI21X1_39/B OAI21X1_39/a_9_54# vdd pfet w=40 l=2
+  ad=0 pd=0 as=0.12n ps=86u
M6730 OAI21X1_39/a_9_54# INVX2_2/A vdd vdd pfet w=40 l=2
+  ad=0 pd=0 as=0 ps=0
M6731 OAI21X1_39/a_2_6# OAI21X1_39/B gnd Gnd nfet w=20 l=2
+  ad=0 pd=0 as=0 ps=0
M6732 gnd invader_bullet_coord_x[2] XNOR2X1_4/a_2_6# Gnd nfet w=20 l=2
+  ad=0 pd=0 as=100p ps=50u
M6733 XNOR2X1_4/Y invader_bullet_coord_x[2] XNOR2X1_4/a_18_6# Gnd nfet w=20 l=2
+  ad=0.2n pd=60u as=59.999996p ps=46u
M6734 XNOR2X1_4/a_12_41# player_coord_x[2] gnd Gnd nfet w=20 l=2
+  ad=100p pd=50u as=0 ps=0
M6735 XNOR2X1_4/a_18_54# XNOR2X1_4/a_12_41# vdd vdd pfet w=40 l=2
+  ad=0.12n pd=86u as=0 ps=0
M6736 XNOR2X1_4/a_35_6# XNOR2X1_4/a_2_6# XNOR2X1_4/Y Gnd nfet w=20 l=2
+  ad=59.999996p pd=46u as=0 ps=0
M6737 XNOR2X1_4/a_18_6# XNOR2X1_4/a_12_41# gnd Gnd nfet w=20 l=2
+  ad=0 pd=0 as=0 ps=0
M6738 vdd invader_bullet_coord_x[2] XNOR2X1_4/a_2_6# vdd pfet w=40 l=2
+  ad=0 pd=0 as=0.2n ps=90u
M6739 vdd player_coord_x[2] XNOR2X1_4/a_35_54# vdd pfet w=40 l=2
+  ad=0 pd=0 as=0.12n ps=86u
M6740 XNOR2X1_4/Y XNOR2X1_4/a_2_6# XNOR2X1_4/a_18_54# vdd pfet w=40 l=2
+  ad=0.4n pd=100u as=0 ps=0
M6741 XNOR2X1_4/a_35_54# invader_bullet_coord_x[2] XNOR2X1_4/Y vdd pfet w=40 l=2
+  ad=0 pd=0 as=0 ps=0
M6742 XNOR2X1_4/a_12_41# player_coord_x[2] vdd vdd pfet w=40 l=2
+  ad=0.2n pd=90u as=0 ps=0
M6743 gnd player_coord_x[2] XNOR2X1_4/a_35_6# Gnd nfet w=20 l=2
+  ad=0 pd=0 as=0 ps=0
M6744 DFFNEGX1_61/a_76_6# BUFX2_3/Y DFFNEGX1_61/a_66_6# Gnd nfet w=10 l=2
+  ad=29.999998p pd=26u as=80p ps=36u
M6745 gnd BUFX2_3/Y DFFNEGX1_61/a_2_6# Gnd nfet w=20 l=2
+  ad=0 pd=0 as=100p ps=50u
M6746 DFFNEGX1_61/a_66_6# DFFNEGX1_61/a_2_6# DFFNEGX1_61/a_61_6# Gnd nfet w=10 l=2
+  ad=0 pd=0 as=29.999998p ps=26u
M6747 shield_coord_y[0] DFFNEGX1_61/a_66_6# gnd Gnd nfet w=20 l=2
+  ad=100p pd=50u as=0 ps=0
M6748 DFFNEGX1_61/a_23_6# BUFX2_3/Y DFFNEGX1_61/a_17_6# Gnd nfet w=10 l=2
+  ad=59.999996p pd=32u as=40p ps=28u
M6749 DFFNEGX1_61/a_23_6# DFFNEGX1_61/a_2_6# DFFNEGX1_61/a_17_74# vdd pfet w=20 l=2
+  ad=0.12n pd=52u as=80p ps=48u
M6750 gnd DFFNEGX1_61/a_34_4# DFFNEGX1_61/a_31_6# Gnd nfet w=10 l=2
+  ad=0 pd=0 as=29.999998p ps=26u
M6751 vdd DFFNEGX1_61/a_34_4# DFFNEGX1_61/a_31_74# vdd pfet w=20 l=2
+  ad=0 pd=0 as=80p ps=48u
M6752 DFFNEGX1_61/a_61_74# DFFNEGX1_61/a_34_4# vdd vdd pfet w=20 l=2
+  ad=59.999996p pd=46u as=0 ps=0
M6753 DFFNEGX1_61/a_34_4# DFFNEGX1_61/a_23_6# vdd vdd pfet w=20 l=2
+  ad=100p pd=50u as=0 ps=0
M6754 DFFNEGX1_61/a_34_4# DFFNEGX1_61/a_23_6# gnd Gnd nfet w=10 l=2
+  ad=50p pd=30u as=0 ps=0
M6755 vdd shield_coord_y[0] DFFNEGX1_61/a_76_84# vdd pfet w=10 l=2
+  ad=0 pd=0 as=29.999998p ps=26u
M6756 gnd shield_coord_y[0] DFFNEGX1_61/a_76_6# Gnd nfet w=10 l=2
+  ad=0 pd=0 as=0 ps=0
M6757 DFFNEGX1_61/a_61_6# DFFNEGX1_61/a_34_4# gnd Gnd nfet w=10 l=2
+  ad=0 pd=0 as=0 ps=0
M6758 DFFNEGX1_61/a_76_84# DFFNEGX1_61/a_2_6# DFFNEGX1_61/a_66_6# vdd pfet w=10 l=2
+  ad=0 pd=0 as=0.15n ps=56u
M6759 shield_coord_y[0] DFFNEGX1_61/a_66_6# vdd vdd pfet w=40 l=2
+  ad=0.2n pd=90u as=0 ps=0
M6760 vdd BUFX2_3/Y DFFNEGX1_61/a_2_6# vdd pfet w=40 l=2
+  ad=0 pd=0 as=0.2n ps=90u
M6761 DFFNEGX1_61/a_31_6# DFFNEGX1_61/a_2_6# DFFNEGX1_61/a_23_6# Gnd nfet w=10 l=2
+  ad=0 pd=0 as=0 ps=0
M6762 DFFNEGX1_61/a_66_6# BUFX2_3/Y DFFNEGX1_61/a_61_74# vdd pfet w=20 l=2
+  ad=0 pd=0 as=0 ps=0
M6763 DFFNEGX1_61/a_17_74# OAI21X1_96/Y vdd vdd pfet w=20 l=2
+  ad=0 pd=0 as=0 ps=0
M6764 DFFNEGX1_61/a_31_74# BUFX2_3/Y DFFNEGX1_61/a_23_6# vdd pfet w=20 l=2
+  ad=0 pd=0 as=0 ps=0
M6765 DFFNEGX1_61/a_17_6# OAI21X1_96/Y gnd Gnd nfet w=10 l=2
+  ad=0 pd=0 as=0 ps=0
M6766 DFFNEGX1_50/a_76_6# BUFX2_4/Y DFFNEGX1_50/a_66_6# Gnd nfet w=10 l=2
+  ad=29.999998p pd=26u as=80p ps=36u
M6767 gnd BUFX2_4/Y DFFNEGX1_50/a_2_6# Gnd nfet w=20 l=2
+  ad=0 pd=0 as=100p ps=50u
M6768 DFFNEGX1_50/a_66_6# DFFNEGX1_50/a_2_6# DFFNEGX1_50/a_61_6# Gnd nfet w=10 l=2
+  ad=0 pd=0 as=29.999998p ps=26u
M6769 invader_1_coord_y[2] DFFNEGX1_50/a_66_6# gnd Gnd nfet w=20 l=2
+  ad=100p pd=50u as=0 ps=0
M6770 DFFNEGX1_50/a_23_6# BUFX2_4/Y DFFNEGX1_50/a_17_6# Gnd nfet w=10 l=2
+  ad=59.999996p pd=32u as=40p ps=28u
M6771 DFFNEGX1_50/a_23_6# DFFNEGX1_50/a_2_6# DFFNEGX1_50/a_17_74# vdd pfet w=20 l=2
+  ad=0.12n pd=52u as=80p ps=48u
M6772 gnd DFFNEGX1_50/a_34_4# DFFNEGX1_50/a_31_6# Gnd nfet w=10 l=2
+  ad=0 pd=0 as=29.999998p ps=26u
M6773 vdd DFFNEGX1_50/a_34_4# DFFNEGX1_50/a_31_74# vdd pfet w=20 l=2
+  ad=0 pd=0 as=80p ps=48u
M6774 DFFNEGX1_50/a_61_74# DFFNEGX1_50/a_34_4# vdd vdd pfet w=20 l=2
+  ad=59.999996p pd=46u as=0 ps=0
M6775 DFFNEGX1_50/a_34_4# DFFNEGX1_50/a_23_6# vdd vdd pfet w=20 l=2
+  ad=100p pd=50u as=0 ps=0
M6776 DFFNEGX1_50/a_34_4# DFFNEGX1_50/a_23_6# gnd Gnd nfet w=10 l=2
+  ad=50p pd=30u as=0 ps=0
M6777 vdd invader_1_coord_y[2] DFFNEGX1_50/a_76_84# vdd pfet w=10 l=2
+  ad=0 pd=0 as=29.999998p ps=26u
M6778 gnd invader_1_coord_y[2] DFFNEGX1_50/a_76_6# Gnd nfet w=10 l=2
+  ad=0 pd=0 as=0 ps=0
M6779 DFFNEGX1_50/a_61_6# DFFNEGX1_50/a_34_4# gnd Gnd nfet w=10 l=2
+  ad=0 pd=0 as=0 ps=0
M6780 DFFNEGX1_50/a_76_84# DFFNEGX1_50/a_2_6# DFFNEGX1_50/a_66_6# vdd pfet w=10 l=2
+  ad=0 pd=0 as=0.15n ps=56u
M6781 invader_1_coord_y[2] DFFNEGX1_50/a_66_6# vdd vdd pfet w=40 l=2
+  ad=0.2n pd=90u as=0 ps=0
M6782 vdd BUFX2_4/Y DFFNEGX1_50/a_2_6# vdd pfet w=40 l=2
+  ad=0 pd=0 as=0.2n ps=90u
M6783 DFFNEGX1_50/a_31_6# DFFNEGX1_50/a_2_6# DFFNEGX1_50/a_23_6# Gnd nfet w=10 l=2
+  ad=0 pd=0 as=0 ps=0
M6784 DFFNEGX1_50/a_66_6# BUFX2_4/Y DFFNEGX1_50/a_61_74# vdd pfet w=20 l=2
+  ad=0 pd=0 as=0 ps=0
M6785 DFFNEGX1_50/a_17_74# OR2X1_9/Y vdd vdd pfet w=20 l=2
+  ad=0 pd=0 as=0 ps=0
M6786 DFFNEGX1_50/a_31_74# BUFX2_4/Y DFFNEGX1_50/a_23_6# vdd pfet w=20 l=2
+  ad=0 pd=0 as=0 ps=0
M6787 DFFNEGX1_50/a_17_6# OR2X1_9/Y gnd Gnd nfet w=10 l=2
+  ad=0 pd=0 as=0 ps=0
M6788 DFFNEGX1_83/a_76_6# BUFX2_2/Y DFFNEGX1_83/a_66_6# Gnd nfet w=10 l=2
+  ad=29.999998p pd=26u as=80p ps=36u
M6789 gnd BUFX2_2/Y DFFNEGX1_83/a_2_6# Gnd nfet w=20 l=2
+  ad=0 pd=0 as=100p ps=50u
M6790 DFFNEGX1_83/a_66_6# DFFNEGX1_83/a_2_6# DFFNEGX1_83/a_61_6# Gnd nfet w=10 l=2
+  ad=0 pd=0 as=29.999998p ps=26u
M6791 INVX2_152/A DFFNEGX1_83/a_66_6# gnd Gnd nfet w=20 l=2
+  ad=100p pd=50u as=0 ps=0
M6792 DFFNEGX1_83/a_23_6# BUFX2_2/Y DFFNEGX1_83/a_17_6# Gnd nfet w=10 l=2
+  ad=59.999996p pd=32u as=40p ps=28u
M6793 DFFNEGX1_83/a_23_6# DFFNEGX1_83/a_2_6# DFFNEGX1_83/a_17_74# vdd pfet w=20 l=2
+  ad=0.12n pd=52u as=80p ps=48u
M6794 gnd DFFNEGX1_83/a_34_4# DFFNEGX1_83/a_31_6# Gnd nfet w=10 l=2
+  ad=0 pd=0 as=29.999998p ps=26u
M6795 vdd DFFNEGX1_83/a_34_4# DFFNEGX1_83/a_31_74# vdd pfet w=20 l=2
+  ad=0 pd=0 as=80p ps=48u
M6796 DFFNEGX1_83/a_61_74# DFFNEGX1_83/a_34_4# vdd vdd pfet w=20 l=2
+  ad=59.999996p pd=46u as=0 ps=0
M6797 DFFNEGX1_83/a_34_4# DFFNEGX1_83/a_23_6# vdd vdd pfet w=20 l=2
+  ad=100p pd=50u as=0 ps=0
M6798 DFFNEGX1_83/a_34_4# DFFNEGX1_83/a_23_6# gnd Gnd nfet w=10 l=2
+  ad=50p pd=30u as=0 ps=0
M6799 vdd INVX2_152/A DFFNEGX1_83/a_76_84# vdd pfet w=10 l=2
+  ad=0 pd=0 as=29.999998p ps=26u
M6800 gnd INVX2_152/A DFFNEGX1_83/a_76_6# Gnd nfet w=10 l=2
+  ad=0 pd=0 as=0 ps=0
M6801 DFFNEGX1_83/a_61_6# DFFNEGX1_83/a_34_4# gnd Gnd nfet w=10 l=2
+  ad=0 pd=0 as=0 ps=0
M6802 DFFNEGX1_83/a_76_84# DFFNEGX1_83/a_2_6# DFFNEGX1_83/a_66_6# vdd pfet w=10 l=2
+  ad=0 pd=0 as=0.15n ps=56u
M6803 INVX2_152/A DFFNEGX1_83/a_66_6# vdd vdd pfet w=40 l=2
+  ad=0.2n pd=90u as=0 ps=0
M6804 vdd BUFX2_2/Y DFFNEGX1_83/a_2_6# vdd pfet w=40 l=2
+  ad=0 pd=0 as=0.2n ps=90u
M6805 DFFNEGX1_83/a_31_6# DFFNEGX1_83/a_2_6# DFFNEGX1_83/a_23_6# Gnd nfet w=10 l=2
+  ad=0 pd=0 as=0 ps=0
M6806 DFFNEGX1_83/a_66_6# BUFX2_2/Y DFFNEGX1_83/a_61_74# vdd pfet w=20 l=2
+  ad=0 pd=0 as=0 ps=0
M6807 DFFNEGX1_83/a_17_74# OAI21X1_122/Y vdd vdd pfet w=20 l=2
+  ad=0 pd=0 as=0 ps=0
M6808 DFFNEGX1_83/a_31_74# BUFX2_2/Y DFFNEGX1_83/a_23_6# vdd pfet w=20 l=2
+  ad=0 pd=0 as=0 ps=0
M6809 DFFNEGX1_83/a_17_6# OAI21X1_122/Y gnd Gnd nfet w=10 l=2
+  ad=0 pd=0 as=0 ps=0
M6810 DFFNEGX1_72/a_76_6# BUFX2_3/Y DFFNEGX1_72/a_66_6# Gnd nfet w=10 l=2
+  ad=29.999998p pd=26u as=80p ps=36u
M6811 gnd BUFX2_3/Y DFFNEGX1_72/a_2_6# Gnd nfet w=20 l=2
+  ad=0 pd=0 as=100p ps=50u
M6812 DFFNEGX1_72/a_66_6# DFFNEGX1_72/a_2_6# DFFNEGX1_72/a_61_6# Gnd nfet w=10 l=2
+  ad=0 pd=0 as=29.999998p ps=26u
M6813 player_coord_x[2] DFFNEGX1_72/a_66_6# gnd Gnd nfet w=20 l=2
+  ad=100p pd=50u as=0 ps=0
M6814 DFFNEGX1_72/a_23_6# BUFX2_3/Y DFFNEGX1_72/a_17_6# Gnd nfet w=10 l=2
+  ad=59.999996p pd=32u as=40p ps=28u
M6815 DFFNEGX1_72/a_23_6# DFFNEGX1_72/a_2_6# DFFNEGX1_72/a_17_74# vdd pfet w=20 l=2
+  ad=0.12n pd=52u as=80p ps=48u
M6816 gnd DFFNEGX1_72/a_34_4# DFFNEGX1_72/a_31_6# Gnd nfet w=10 l=2
+  ad=0 pd=0 as=29.999998p ps=26u
M6817 vdd DFFNEGX1_72/a_34_4# DFFNEGX1_72/a_31_74# vdd pfet w=20 l=2
+  ad=0 pd=0 as=80p ps=48u
M6818 DFFNEGX1_72/a_61_74# DFFNEGX1_72/a_34_4# vdd vdd pfet w=20 l=2
+  ad=59.999996p pd=46u as=0 ps=0
M6819 DFFNEGX1_72/a_34_4# DFFNEGX1_72/a_23_6# vdd vdd pfet w=20 l=2
+  ad=100p pd=50u as=0 ps=0
M6820 DFFNEGX1_72/a_34_4# DFFNEGX1_72/a_23_6# gnd Gnd nfet w=10 l=2
+  ad=50p pd=30u as=0 ps=0
M6821 vdd player_coord_x[2] DFFNEGX1_72/a_76_84# vdd pfet w=10 l=2
+  ad=0 pd=0 as=29.999998p ps=26u
M6822 gnd player_coord_x[2] DFFNEGX1_72/a_76_6# Gnd nfet w=10 l=2
+  ad=0 pd=0 as=0 ps=0
M6823 DFFNEGX1_72/a_61_6# DFFNEGX1_72/a_34_4# gnd Gnd nfet w=10 l=2
+  ad=0 pd=0 as=0 ps=0
M6824 DFFNEGX1_72/a_76_84# DFFNEGX1_72/a_2_6# DFFNEGX1_72/a_66_6# vdd pfet w=10 l=2
+  ad=0 pd=0 as=0.15n ps=56u
M6825 player_coord_x[2] DFFNEGX1_72/a_66_6# vdd vdd pfet w=40 l=2
+  ad=0.2n pd=90u as=0 ps=0
M6826 vdd BUFX2_3/Y DFFNEGX1_72/a_2_6# vdd pfet w=40 l=2
+  ad=0 pd=0 as=0.2n ps=90u
M6827 DFFNEGX1_72/a_31_6# DFFNEGX1_72/a_2_6# DFFNEGX1_72/a_23_6# Gnd nfet w=10 l=2
+  ad=0 pd=0 as=0 ps=0
M6828 DFFNEGX1_72/a_66_6# BUFX2_3/Y DFFNEGX1_72/a_61_74# vdd pfet w=20 l=2
+  ad=0 pd=0 as=0 ps=0
M6829 DFFNEGX1_72/a_17_74# NAND2X1_52/Y vdd vdd pfet w=20 l=2
+  ad=0 pd=0 as=0 ps=0
M6830 DFFNEGX1_72/a_31_74# BUFX2_3/Y DFFNEGX1_72/a_23_6# vdd pfet w=20 l=2
+  ad=0 pd=0 as=0 ps=0
M6831 DFFNEGX1_72/a_17_6# NAND2X1_52/Y gnd Gnd nfet w=10 l=2
+  ad=0 pd=0 as=0 ps=0
M6832 vdd invader_1_coord_y[1] HAX1_8/a_2_74# vdd pfet w=20 l=2
+  ad=0 pd=0 as=0.2n ps=100u
M6833 HAX1_8/a_41_74# HAX1_8/a_2_74# vdd vdd pfet w=20 l=2
+  ad=0.22n pd=92u as=0 ps=0
M6834 HAX1_8/a_9_6# invader_1_coord_y[1] gnd Gnd nfet w=20 l=2
+  ad=59.999996p pd=46u as=0 ps=0
M6835 HAX1_8/a_41_74# invader_1_coord_y[0] HAX1_8/a_38_6# Gnd nfet w=20 l=2
+  ad=0.12n pd=52u as=0.216n ps=0.102m
M6836 vdd invader_1_coord_y[1] HAX1_8/a_49_54# vdd pfet w=40 l=2
+  ad=0 pd=0 as=0.12n ps=86u
M6837 vdd HAX1_8/a_2_74# HAX1_7/B vdd pfet w=20 l=2
+  ad=0 pd=0 as=100p ps=50u
M6838 HAX1_8/a_38_6# HAX1_8/a_2_74# gnd Gnd nfet w=20 l=2
+  ad=0 pd=0 as=0 ps=0
M6839 HAX1_8/YS HAX1_8/a_41_74# vdd vdd pfet w=20 l=2
+  ad=100p pd=50u as=0 ps=0
M6840 HAX1_8/a_38_6# invader_1_coord_y[1] HAX1_8/a_41_74# Gnd nfet w=20 l=2
+  ad=0 pd=0 as=0 ps=0
M6841 HAX1_8/YS HAX1_8/a_41_74# gnd Gnd nfet w=10 l=2
+  ad=50p pd=30u as=0 ps=0
M6842 HAX1_8/a_2_74# invader_1_coord_y[0] vdd vdd pfet w=20 l=2
+  ad=0 pd=0 as=0 ps=0
M6843 HAX1_8/a_2_74# invader_1_coord_y[0] HAX1_8/a_9_6# Gnd nfet w=20 l=2
+  ad=100p pd=50u as=0 ps=0
M6844 HAX1_8/a_49_54# invader_1_coord_y[0] HAX1_8/a_41_74# vdd pfet w=40 l=2
+  ad=0 pd=0 as=0 ps=0
M6845 gnd HAX1_8/a_2_74# HAX1_7/B Gnd nfet w=10 l=2
+  ad=0 pd=0 as=50p ps=30u
M6846 AND2X2_4/a_2_6# invader_bullet_coord_x[1] vdd vdd pfet w=20 l=2
+  ad=0.12n pd=52u as=0 ps=0
M6847 AND2X2_4/a_9_6# invader_bullet_coord_x[1] AND2X2_4/a_2_6# Gnd nfet w=20 l=2
+  ad=59.999996p pd=46u as=100p ps=50u
M6848 XOR2X1_2/A AND2X2_4/a_2_6# gnd Gnd nfet w=20 l=2
+  ad=100p pd=50u as=0 ps=0
M6849 XOR2X1_2/A AND2X2_4/a_2_6# vdd vdd pfet w=40 l=2
+  ad=0.2n pd=90u as=0 ps=0
M6850 vdd invader_bullet_coord_x[2] AND2X2_4/a_2_6# vdd pfet w=20 l=2
+  ad=0 pd=0 as=0 ps=0
M6851 gnd invader_bullet_coord_x[2] AND2X2_4/a_9_6# Gnd nfet w=20 l=2
+  ad=0 pd=0 as=0 ps=0
M6852 NAND2X1_31/Y XOR2X1_7/A vdd vdd pfet w=20 l=2
+  ad=0.12n pd=52u as=0 ps=0
M6853 NAND2X1_31/a_9_6# XOR2X1_7/A gnd Gnd nfet w=20 l=2
+  ad=59.999996p pd=46u as=0 ps=0
M6854 vdd invader_2_coord_x[3] NAND2X1_31/Y vdd pfet w=20 l=2
+  ad=0 pd=0 as=0 ps=0
M6855 NAND2X1_31/Y invader_2_coord_x[3] NAND2X1_31/a_9_6# Gnd nfet w=20 l=2
+  ad=100p pd=50u as=0 ps=0
M6856 NAND3X1_6/A INVX2_68/Y vdd vdd pfet w=20 l=2
+  ad=0.12n pd=52u as=0 ps=0
M6857 NAND2X1_20/a_9_6# INVX2_68/Y gnd Gnd nfet w=20 l=2
+  ad=59.999996p pd=46u as=0 ps=0
M6858 vdd INVX2_18/Y NAND3X1_6/A vdd pfet w=20 l=2
+  ad=0 pd=0 as=0 ps=0
M6859 NAND3X1_6/A INVX2_18/Y NAND2X1_20/a_9_6# Gnd nfet w=20 l=2
+  ad=100p pd=50u as=0 ps=0
M6860 OR2X1_9/A INVX2_135/Y vdd vdd pfet w=20 l=2
+  ad=0.12n pd=52u as=0 ps=0
M6861 NAND2X1_42/a_9_6# INVX2_135/Y gnd Gnd nfet w=20 l=2
+  ad=59.999996p pd=46u as=0 ps=0
M6862 vdd OAI21X1_74/A OR2X1_9/A vdd pfet w=20 l=2
+  ad=0 pd=0 as=0 ps=0
M6863 OR2X1_9/A OAI21X1_74/A NAND2X1_42/a_9_6# Gnd nfet w=20 l=2
+  ad=100p pd=50u as=0 ps=0
M6864 NAND2X1_64/Y INVX2_123/Y vdd vdd pfet w=20 l=2
+  ad=0.12n pd=52u as=0 ps=0
M6865 NAND2X1_64/a_9_6# INVX2_123/Y gnd Gnd nfet w=20 l=2
+  ad=59.999996p pd=46u as=0 ps=0
M6866 vdd NAND2X1_64/B NAND2X1_64/Y vdd pfet w=20 l=2
+  ad=0 pd=0 as=0 ps=0
M6867 NAND2X1_64/Y NAND2X1_64/B NAND2X1_64/a_9_6# Gnd nfet w=20 l=2
+  ad=100p pd=50u as=0 ps=0
M6868 NAND2X1_53/Y NAND2X1_53/A vdd vdd pfet w=20 l=2
+  ad=0.12n pd=52u as=0 ps=0
M6869 NAND2X1_53/a_9_6# NAND2X1_53/A gnd Gnd nfet w=20 l=2
+  ad=59.999996p pd=46u as=0 ps=0
M6870 vdd AND2X2_19/Y NAND2X1_53/Y vdd pfet w=20 l=2
+  ad=0 pd=0 as=0 ps=0
M6871 NAND2X1_53/Y AND2X2_19/Y NAND2X1_53/a_9_6# Gnd nfet w=20 l=2
+  ad=100p pd=50u as=0 ps=0
M6872 INVX2_99/A player_coord_x[0] vdd vdd pfet w=20 l=2
+  ad=0.12n pd=52u as=0 ps=0
M6873 NAND2X1_75/a_9_6# player_coord_x[0] gnd Gnd nfet w=20 l=2
+  ad=59.999996p pd=46u as=0 ps=0
M6874 vdd INVX2_25/Y INVX2_99/A vdd pfet w=20 l=2
+  ad=0 pd=0 as=0 ps=0
M6875 INVX2_99/A INVX2_25/Y NAND2X1_75/a_9_6# Gnd nfet w=20 l=2
+  ad=100p pd=50u as=0 ps=0
M6876 gnd INVX2_131/Y AOI22X1_40/a_28_6# Gnd nfet w=20 l=2
+  ad=0 pd=0 as=59.999996p ps=46u
M6877 NAND2X1_52/A AOI22X1_40/B AOI22X1_40/a_11_6# Gnd nfet w=20 l=2
+  ad=0.2n pd=60u as=59.999996p ps=46u
M6878 AOI22X1_40/a_11_6# INVX2_97/A gnd Gnd nfet w=20 l=2
+  ad=0 pd=0 as=0 ps=0
M6879 AOI22X1_40/a_2_54# AOI22X1_40/B vdd vdd pfet w=40 l=2
+  ad=0.64n pd=0.272m as=0 ps=0
M6880 AOI22X1_40/a_28_6# player_coord_x[2] NAND2X1_52/A Gnd nfet w=20 l=2
+  ad=0 pd=0 as=0 ps=0
M6881 vdd INVX2_97/A AOI22X1_40/a_2_54# vdd pfet w=40 l=2
+  ad=0 pd=0 as=0 ps=0
M6882 NAND2X1_52/A player_coord_x[2] AOI22X1_40/a_2_54# vdd pfet w=40 l=2
+  ad=0.24n pd=92u as=0 ps=0
M6883 AOI22X1_40/a_2_54# INVX2_131/Y NAND2X1_52/A vdd pfet w=40 l=2
+  ad=0 pd=0 as=0 ps=0
M6884 gnd invader_2_coord_y[0] AOI22X1_51/a_28_6# Gnd nfet w=20 l=2
+  ad=0 pd=0 as=59.999996p ps=46u
M6885 INVX2_114/A OAI22X1_8/A AOI22X1_51/a_11_6# Gnd nfet w=20 l=2
+  ad=0.2n pd=60u as=59.999996p ps=46u
M6886 AOI22X1_51/a_11_6# invader_1_coord_y[0] gnd Gnd nfet w=20 l=2
+  ad=0 pd=0 as=0 ps=0
M6887 AOI22X1_51/a_2_54# OAI22X1_8/A vdd vdd pfet w=40 l=2
+  ad=0.64n pd=0.272m as=0 ps=0
M6888 AOI22X1_51/a_28_6# OAI22X1_8/D INVX2_114/A Gnd nfet w=20 l=2
+  ad=0 pd=0 as=0 ps=0
M6889 vdd invader_1_coord_y[0] AOI22X1_51/a_2_54# vdd pfet w=40 l=2
+  ad=0 pd=0 as=0 ps=0
M6890 INVX2_114/A OAI22X1_8/D AOI22X1_51/a_2_54# vdd pfet w=40 l=2
+  ad=0.24n pd=92u as=0 ps=0
M6891 AOI22X1_51/a_2_54# invader_2_coord_y[0] INVX2_114/A vdd pfet w=40 l=2
+  ad=0 pd=0 as=0 ps=0
M6892 gnd AOI22X1_62/C AOI22X1_62/a_28_6# Gnd nfet w=20 l=2
+  ad=0 pd=0 as=59.999996p ps=46u
M6893 NAND2X1_76/A INVX2_110/Y AOI22X1_62/a_11_6# Gnd nfet w=20 l=2
+  ad=0.2n pd=60u as=59.999996p ps=46u
M6894 AOI22X1_62/a_11_6# NOR2X1_57/Y gnd Gnd nfet w=20 l=2
+  ad=0 pd=0 as=0 ps=0
M6895 AOI22X1_62/a_2_54# INVX2_110/Y vdd vdd pfet w=40 l=2
+  ad=0.64n pd=0.272m as=0 ps=0
M6896 AOI22X1_62/a_28_6# XOR2X1_20/Y NAND2X1_76/A Gnd nfet w=20 l=2
+  ad=0 pd=0 as=0 ps=0
M6897 vdd NOR2X1_57/Y AOI22X1_62/a_2_54# vdd pfet w=40 l=2
+  ad=0 pd=0 as=0 ps=0
M6898 NAND2X1_76/A XOR2X1_20/Y AOI22X1_62/a_2_54# vdd pfet w=40 l=2
+  ad=0.24n pd=92u as=0 ps=0
M6899 AOI22X1_62/a_2_54# AOI22X1_62/C NAND2X1_76/A vdd pfet w=40 l=2
+  ad=0 pd=0 as=0 ps=0
M6900 gnd player_bullet_coord_x[1] OAI22X1_2/a_2_6# Gnd nfet w=20 l=2
+  ad=0 pd=0 as=0.32n ps=0.152m
M6901 OAI22X1_2/a_2_6# player_bullet_coord_x[0] OAI22X1_2/Y Gnd nfet w=20 l=2
+  ad=0 pd=0 as=0.12n ps=52u
M6902 OAI22X1_2/Y invader_1_coord_x[0] OAI22X1_2/a_2_6# Gnd nfet w=20 l=2
+  ad=0 pd=0 as=0 ps=0
M6903 OAI22X1_2/Y INVX2_63/A OAI22X1_2/a_9_54# vdd pfet w=40 l=2
+  ad=0.48n pd=0.104m as=0.12n ps=86u
M6904 OAI22X1_2/a_28_54# invader_1_coord_x[0] OAI22X1_2/Y vdd pfet w=40 l=2
+  ad=0.12n pd=86u as=0 ps=0
M6905 OAI22X1_2/a_9_54# player_bullet_coord_x[1] vdd vdd pfet w=40 l=2
+  ad=0 pd=0 as=0 ps=0
M6906 OAI22X1_2/a_2_6# INVX2_63/A gnd Gnd nfet w=20 l=2
+  ad=0 pd=0 as=0 ps=0
M6907 vdd player_bullet_coord_x[0] OAI22X1_2/a_28_54# vdd pfet w=40 l=2
+  ad=0 pd=0 as=0 ps=0
M6908 INVX2_11/Y invader_bullet_coord_y[1] gnd Gnd nfet w=20 l=2
+  ad=100p pd=50u as=0 ps=0
M6909 INVX2_11/Y invader_bullet_coord_y[1] vdd vdd pfet w=40 l=2
+  ad=0.2n pd=90u as=0 ps=0
M6910 INVX2_22/Y player_bullet_coord_y[1] gnd Gnd nfet w=20 l=2
+  ad=100p pd=50u as=0 ps=0
M6911 INVX2_22/Y player_bullet_coord_y[1] vdd vdd pfet w=40 l=2
+  ad=0.2n pd=90u as=0 ps=0
M6912 INVX2_44/Y invader_2_coord_x[2] gnd Gnd nfet w=20 l=2
+  ad=100p pd=50u as=0 ps=0
M6913 INVX2_44/Y invader_2_coord_x[2] vdd vdd pfet w=40 l=2
+  ad=0.2n pd=90u as=0 ps=0
M6914 INVX2_33/Y invader_2_display gnd Gnd nfet w=20 l=2
+  ad=100p pd=50u as=0 ps=0
M6915 INVX2_33/Y invader_2_display vdd vdd pfet w=40 l=2
+  ad=0.2n pd=90u as=0 ps=0
M6916 INVX2_88/Y INVX2_88/A gnd Gnd nfet w=20 l=2
+  ad=100p pd=50u as=0 ps=0
M6917 INVX2_88/Y INVX2_88/A vdd vdd pfet w=40 l=2
+  ad=0.2n pd=90u as=0 ps=0
M6918 INVX2_77/Y HAX1_6/YS gnd Gnd nfet w=20 l=2
+  ad=100p pd=50u as=0 ps=0
M6919 INVX2_77/Y HAX1_6/YS vdd vdd pfet w=40 l=2
+  ad=0.2n pd=90u as=0 ps=0
M6920 INVX2_55/Y invader_1_coord_x[0] gnd Gnd nfet w=20 l=2
+  ad=100p pd=50u as=0 ps=0
M6921 INVX2_55/Y invader_1_coord_x[0] vdd vdd pfet w=40 l=2
+  ad=0.2n pd=90u as=0 ps=0
M6922 INVX2_66/Y HAX1_9/YS gnd Gnd nfet w=20 l=2
+  ad=100p pd=50u as=0 ps=0
M6923 INVX2_66/Y HAX1_9/YS vdd vdd pfet w=40 l=2
+  ad=0.2n pd=90u as=0 ps=0
M6924 INVX2_99/Y INVX2_99/A gnd Gnd nfet w=20 l=2
+  ad=100p pd=50u as=0 ps=0
M6925 INVX2_99/Y INVX2_99/A vdd vdd pfet w=40 l=2
+  ad=0.2n pd=90u as=0 ps=0
M6926 gnd INVX2_173/Y OAI21X1_29/a_2_6# Gnd nfet w=20 l=2
+  ad=0 pd=0 as=0.22n ps=0.102m
M6927 vdd AOI22X1_8/Y OAI21X1_29/Y vdd pfet w=20 l=2
+  ad=0 pd=0 as=0.22n ps=92u
M6928 OAI21X1_29/Y AOI22X1_8/Y OAI21X1_29/a_2_6# Gnd nfet w=20 l=2
+  ad=100p pd=50u as=0 ps=0
M6929 OAI21X1_29/Y INVX2_6/Y OAI21X1_29/a_9_54# vdd pfet w=40 l=2
+  ad=0 pd=0 as=0.12n ps=86u
M6930 OAI21X1_29/a_9_54# INVX2_173/Y vdd vdd pfet w=40 l=2
+  ad=0 pd=0 as=0 ps=0
M6931 OAI21X1_29/a_2_6# INVX2_6/Y gnd Gnd nfet w=20 l=2
+  ad=0 pd=0 as=0 ps=0
M6932 gnd INVX2_63/Y OAI21X1_18/a_2_6# Gnd nfet w=20 l=2
+  ad=0 pd=0 as=0.22n ps=0.102m
M6933 vdd OAI22X1_2/Y OAI21X1_18/Y vdd pfet w=20 l=2
+  ad=0 pd=0 as=0.22n ps=92u
M6934 OAI21X1_18/Y OAI22X1_2/Y OAI21X1_18/a_2_6# Gnd nfet w=20 l=2
+  ad=100p pd=50u as=0 ps=0
M6935 OAI21X1_18/Y OAI21X1_4/B OAI21X1_18/a_9_54# vdd pfet w=40 l=2
+  ad=0 pd=0 as=0.12n ps=86u
M6936 OAI21X1_18/a_9_54# INVX2_63/Y vdd vdd pfet w=40 l=2
+  ad=0 pd=0 as=0 ps=0
M6937 OAI21X1_18/a_2_6# OAI21X1_4/B gnd Gnd nfet w=20 l=2
+  ad=0 pd=0 as=0 ps=0
M6938 gnd XNOR2X1_6/B XNOR2X1_5/a_2_6# Gnd nfet w=20 l=2
+  ad=0 pd=0 as=100p ps=50u
M6939 XNOR2X1_5/Y XNOR2X1_6/B XNOR2X1_5/a_18_6# Gnd nfet w=20 l=2
+  ad=0.2n pd=60u as=59.999996p ps=46u
M6940 XNOR2X1_5/a_12_41# XNOR2X1_5/B gnd Gnd nfet w=20 l=2
+  ad=100p pd=50u as=0 ps=0
M6941 XNOR2X1_5/a_18_54# XNOR2X1_5/a_12_41# vdd vdd pfet w=40 l=2
+  ad=0.12n pd=86u as=0 ps=0
M6942 XNOR2X1_5/a_35_6# XNOR2X1_5/a_2_6# XNOR2X1_5/Y Gnd nfet w=20 l=2
+  ad=59.999996p pd=46u as=0 ps=0
M6943 XNOR2X1_5/a_18_6# XNOR2X1_5/a_12_41# gnd Gnd nfet w=20 l=2
+  ad=0 pd=0 as=0 ps=0
M6944 vdd XNOR2X1_6/B XNOR2X1_5/a_2_6# vdd pfet w=40 l=2
+  ad=0 pd=0 as=0.2n ps=90u
M6945 vdd XNOR2X1_5/B XNOR2X1_5/a_35_54# vdd pfet w=40 l=2
+  ad=0 pd=0 as=0.12n ps=86u
M6946 XNOR2X1_5/Y XNOR2X1_5/a_2_6# XNOR2X1_5/a_18_54# vdd pfet w=40 l=2
+  ad=0.4n pd=100u as=0 ps=0
M6947 XNOR2X1_5/a_35_54# XNOR2X1_6/B XNOR2X1_5/Y vdd pfet w=40 l=2
+  ad=0 pd=0 as=0 ps=0
M6948 XNOR2X1_5/a_12_41# XNOR2X1_5/B vdd vdd pfet w=40 l=2
+  ad=0.2n pd=90u as=0 ps=0
M6949 gnd XNOR2X1_5/B XNOR2X1_5/a_35_6# Gnd nfet w=20 l=2
+  ad=0 pd=0 as=0 ps=0
C0 vdd INVX2_176/Y 6.3621f
C1 vdd INVX2_185/A 2.64204f
C2 vdd NAND2X1_1/B 25.541454f
C3 vdd INVX2_89/Y 2.241f
C4 OR2X1_20/A vdd 2.07513f
C5 HAX1_4/YS vdd 2.31921f
C6 vdd INVX2_168/Y 2.01033f
C7 vdd invader_bullet_coord_x[1] 6.09813f
C8 vdd NOR2X1_54/Y 2.884141f
C9 vdd BUFX2_5/Y 18.730795f
C10 vdd NOR2X1_28/A 3.22425f
C11 vdd AND2X2_15/Y 3.28437f
C12 vdd INVX2_148/A 3.33324f
C13 vdd INVX2_182/Y 5.064391f
C14 vdd INVX2_44/Y 4.40361f
C15 gnd BUFX2_3/Y 3.25458f
C16 INVX2_158/A vdd 4.33449f
C17 vdd INVX2_19/Y 2.01852f
C18 vdd shield_coord_x[2] 4.380751f
C19 vdd invader_1_coord_x[1] 5.248981f
C20 vdd invader_1_coord_y[0] 5.43384f
C21 vdd invader_bullet_coord_y[1] 3.545731f
C22 vdd invader_2_coord_y[1] 4.323421f
C23 vdd AND2X2_9/B 2.22021f
C24 invader_bullet_coord_x[2] vdd 4.17105f
C25 vdd AND2X2_19/Y 2.99367f
C26 gnd BUFX2_6/Y 4.54167f
C27 vdd invader_1_coord_y[2] 3.49461f
C28 AND2X2_18/B vdd 2.34891f
C29 vdd OAI22X1_8/D 3.50874f
C30 vdd clkb 2.14614f
C31 vdd OAI22X1_5/B 3.94641f
C32 vdd BUFX2_7/A 2.93868f
C33 vdd HAX1_10/YS 2.36079f
C34 vdd player_bullet_coord_x[2] 5.61897f
C35 vdd invader_bullet_coord_x[0] 3.4281f
C36 vdd AND2X2_8/A 5.37237f
C37 vdd BUFX2_2/Y 13.976458f
C38 vdd BUFX2_7/Y 12.892857f
C39 vdd clka 21.325949f
C40 vdd INVX2_88/A 2.9403f
C41 vdd INVX2_27/A 2.74455f
C42 vdd INVX2_2/A 3.21849f
C43 vdd INVX2_138/Y 3.732661f
C44 INVX2_165/Y vdd 6.39171f
C45 vdd INVX2_56/A 2.25198f
C46 invader_1_coord_y[3] vdd 4.6962f
C47 vdd INVX2_53/A 2.48148f
C48 INVX2_135/Y vdd 3.82005f
C49 NOR2X1_32/B vdd 2.50443f
C50 vdd INVX2_28/A 2.17395f
C51 invader_2_coord_x[2] vdd 7.85916f
C52 OR2X1_19/Y vdd 3.07287f
C53 BUFX2_4/Y vdd 20.284288f
C54 INVX2_124/A vdd 2.58327f
C55 vdd INVX2_144/A 2.06037f
C56 vdd invader_1_display 6.23754f
C57 AND2X2_0/A vdd 6.799769f
C58 vdd INVX2_4/Y 2.19375f
C59 vdd INVX2_83/A 2.74446f
C60 vdd invader_2_coord_x[0] 4.97205f
C61 vdd INVX2_15/Y 2.32506f
C62 vdd AOI21X1_8/Y 2.02185f
C63 shield_hp[1] vdd 3.493351f
C64 invader_2_coord_y[0] vdd 3.08277f
C65 vdd invader_bullet_coord_y[2] 3.99528f
C66 vdd player_coord_x[3] 11.525666f
C67 vdd INVX2_18/Y 4.842091f
C68 vdd INVX2_26/A 2.8278f
C69 INVX2_58/A vdd 2.7063f
C70 vdd invader_1_coord_x[2] 4.44996f
C71 INVX2_126/A vdd 2.21679f
C72 vdd player_coord_x[2] 10.929869f
C73 vdd NOR2X1_23/B 2.04885f
C74 NOR2X1_45/Y vdd 2.6028f
C75 gnd BUFX2_2/Y 2.06802f
C76 INVX2_161/Y vdd 3.39633f
C77 INVX2_116/A vdd 2.29878f
C78 vdd player_bullet_coord_x[1] 6.287491f
C79 gnd BUFX2_7/Y 2.97378f
C80 gnd clka 3.739412f
C81 vdd INVX2_23/Y 4.00473f
C82 vdd player_bullet_coord_x[0] 5.3982f
C83 vdd INVX2_57/A 2.68227f
C84 vdd OR2X1_15/A 10.649516f
C85 vdd INVX2_125/A 2.15073f
C86 vdd invader_bullet_coord_y[0] 4.969981f
C87 vdd OR2X1_17/A 7.416002f
C88 invader_bullet_coord_y[3] vdd 3.617191f
C89 player_bullet_coord_y[0] vdd 4.49541f
C90 vdd INVX2_12/Y 2.53476f
C91 vdd player_bullet_coord_x[3] 8.365049f
C92 vdd AND2X2_14/B 2.58345f
C93 vdd NAND2X1_1/Y 4.33215f
C94 vdd AND2X2_10/Y 2.04363f
C95 vdd player_display 2.67219f
C96 NOR2X1_35/B vdd 3.01401f
C97 vdd player_coord_x[0] 9.571769f
C98 gnd BUFX2_4/Y 2.12121f
C99 OAI22X1_4/B vdd 2.53827f
C100 vdd invader_bullet_coord_x[3] 4.53357f
C101 vdd player_coord_x[1] 7.701031f
C102 gnd invader_1_display 3.1536f
C103 vdd INVX2_133/Y 5.33475f
C104 vdd invader_1_coord_y[1] 3.61467f
C105 INVX2_144/Y vdd 3.857941f
C106 INVX2_89/A vdd 2.44908f
C107 vdd INVX2_7/Y 3.53178f
C108 shield_coord_y[0] vdd 2.66283f
C109 vdd invader_2_coord_y[3] 5.833531f
C110 vdd invader_1_coord_x[0] 4.380301f
C111 vdd INVX2_59/A 2.24235f
C112 invader_2_coord_y[0] gnd 2.59911f
C113 vdd LATCH_2/CLK 2.57112f
C114 vdd invader_2_display 4.15467f
C115 vdd INVX2_146/A 2.45412f
C116 vdd invader_2_coord_x[3] 6.23619f
C117 vdd player_bullet_coord_y[3] 3.32469f
C118 gnd vdd 6.48f
C119 gnd player_bullet_coord_x[1] 2.67084f
C120 vdd invader_1_coord_x[3] 6.448411f
C121 vdd player_bullet_coord_y[2] 7.403491f
C122 vdd INVX2_22/Y 3.34872f
C123 vdd INVX2_153/A 9.801896f
C124 gnd OR2X1_15/A 4.716451f
C125 OR2X1_16/Y vdd 2.01123f
C126 vdd shield_coord_x[1] 5.097961f
C127 vdd INVX2_64/Y 5.137741f
C128 vdd NOR2X1_34/Y 2.07144f
C129 NAND2X1_74/Y vdd 2.3877f
C130 vdd NOR2X1_31/Y 3.28185f
C131 vdd AOI22X1_48/C 2.07558f
C132 vdd INVX2_166/A 2.76876f
C133 vdd INVX2_17/A 2.43126f
C134 INVX2_175/Y vdd 3.511981f
C135 vdd INVX2_2/Y 2.52027f
C136 vdd AND2X2_18/Y 2.01402f
C137 vdd INVX2_95/A 2.15577f
C138 vdd invader_2_coord_x[1] 3.55959f
C139 vdd INVX2_55/Y 4.38228f
C140 gnd player_coord_x[1] 2.33307f
C141 gnd invader_1_coord_y[1] 2.41416f
C142 vdd BUFX2_3/Y 13.306499f
C143 vdd invader_2_coord_y[2] 4.711861f
C144 vdd INVX2_149/A 3.4488f
C145 OR2X1_8/B vdd 2.56149f
C146 vdd OAI22X1_7/B 2.10213f
C147 vdd player_bullet_coord_y[1] 5.49135f
C148 vdd INVX2_16/A 2.88441f
C149 vdd BUFX2_6/Y 16.339499f
C150 INVX2_136/Y vdd 2.56752f
C151 INVX2_25/Y vdd 3.30471f
C152 INVX2_150/Y vdd 2.31768f
C153 vdd OR2X1_15/B 2.05947f
C154 invader_bullet_coord_y[2] 0 46.920433f **FLOATING
C155 player_right_input 0 21.194681f **FLOATING
C156 NOR2X1_42/Y 0 11.426519f **FLOATING
C157 NOR2X1_41/Y 0 9.62466f **FLOATING
C158 NOR2X1_40/Y 0 11.98734f **FLOATING
C159 NOR2X1_60/Y 0 12.82626f **FLOATING
C160 INVX2_87/Y 0 11.132311f **FLOATING
C161 NOR2X1_40/B 0 8.93538f **FLOATING
C162 NOR2X1_60/B 0 19.44948f **FLOATING
C163 NOR2X1_49/Y 0 12.98613f **FLOATING
C164 OR2X1_12/B 0 22.23165f **FLOATING
C165 clka 0 0.249179p **FLOATING
C166 NOR2X1_59/A 0 12.356819f **FLOATING
C167 NOR2X1_54/Y 0 64.79776f **FLOATING
C168 INVX2_98/A 0 22.411106f **FLOATING
C169 INVX2_95/A 0 31.017597f **FLOATING
C170 OR2X1_15/B 0 24.140013f **FLOATING
C171 shield_coord_x[2] 0 47.304832f **FLOATING
C172 NOR2X1_38/Y 0 10.627561f **FLOATING
C173 NOR2X1_54/A 0 15.684719f **FLOATING
C174 OR2X1_18/A 0 22.45884f **FLOATING
C175 INVX2_153/Y 0 7.8669f **FLOATING
C176 INVX2_153/A 0 57.323734f **FLOATING
C177 NOR2X1_39/Y 0 11.0568f **FLOATING
C178 OAI21X1_126/Y 0 12.286019f **FLOATING
C179 INVX2_125/A 0 21.299131f **FLOATING
C180 player_coord_x[0] 0 0.11598p **FLOATING
C181 INVX2_88/Y 0 17.746923f **FLOATING
C182 INVX2_151/A 0 13.662511f **FLOATING
C183 INVX2_124/Y 0 8.46378f **FLOATING
C184 OR2X1_14/Y 0 10.6077f **FLOATING
C185 NAND2X1_1/B 0 0.226707p **FLOATING
C186 invader_bullet_coord_y[1] 0 50.67047f **FLOATING
C187 NAND3X1_46/Y 0 13.61943f **FLOATING
C188 INVX2_159/A 0 26.240488f **FLOATING
C189 OR2X1_13/Y 0 26.476692f **FLOATING
C190 OR2X1_11/B 0 11.78112f **FLOATING
C191 AND2X2_25/B 0 20.260738f **FLOATING
C192 player_coord_x[1] 0 0.123086p **FLOATING
C193 OAI21X1_99/B 0 16.617418f **FLOATING
C194 INVX2_169/A 0 8.57166f **FLOATING
C195 OAI21X1_102/Y 0 11.53932f **FLOATING
C196 INVX2_182/Y 0 71.02344f **FLOATING
C197 INVX2_85/Y 0 21.847137f **FLOATING
C198 OR2X1_11/Y 0 11.93874f **FLOATING
C199 NOR2X1_44/B 0 14.08158f **FLOATING
C200 NAND3X1_44/A 0 13.874821f **FLOATING
C201 AND2X2_18/Y 0 15.76455f **FLOATING
C202 INVX2_162/Y 0 12.031381f **FLOATING
C203 player_coord_x[3] 0 0.118767p **FLOATING
C204 AOI22X1_41/Y 0 9.375301f **FLOATING
C205 INVX2_176/Y 0 65.8771f **FLOATING
C206 AOI22X1_48/C 0 21.833292f **FLOATING
C207 INVX2_83/Y 0 10.9026f **FLOATING
C208 player_coord_x[2] 0 0.134637p **FLOATING
C209 INVX2_170/Y 0 9.53928f **FLOATING
C210 INVX2_172/Y 0 10.631581f **FLOATING
C211 NOR2X1_46/Y 0 9.46782f **FLOATING
C212 INVX2_163/Y 0 12.639899f **FLOATING
C213 player_display 0 35.603447f **FLOATING
C214 AOI22X1_48/A 0 13.62825f **FLOATING
C215 INVX2_172/A 0 10.27458f **FLOATING
C216 NOR2X1_20/Y 0 15.979543f **FLOATING
C217 invader_bullet_coord_x[1] 0 76.45228f **FLOATING
C218 NOR2X1_22/Y 0 22.52904f **FLOATING
C219 NOR2X1_20/A 0 17.610332f **FLOATING
C220 AOI22X1_9/D 0 9.809791f **FLOATING
C221 NAND2X1_60/Y 0 11.34834f **FLOATING
C222 NOR2X1_21/Y 0 9.05238f **FLOATING
C223 AOI22X1_9/C 0 8.144759f **FLOATING
C224 NAND2X1_58/Y 0 9.869162f **FLOATING
C225 OAI21X1_93/Y 0 11.009221f **FLOATING
C226 NOR2X1_19/A 0 10.027381f **FLOATING
C227 HAX1_3/B 0 12.93384f **FLOATING
C228 INVX2_7/Y 0 33.347424f **FLOATING
C229 INVX2_91/Y 0 18.731909f **FLOATING
C230 XOR2X1_1/Y 0 18.41322f **FLOATING
C231 INVX2_4/Y 0 41.77097f **FLOATING
C232 AOI22X1_13/Y 0 9.15222f **FLOATING
C233 NAND2X1_26/A 0 10.960979f **FLOATING
C234 OR2X1_13/B 0 14.10249f **FLOATING
C235 NAND2X1_57/Y 0 10.5708f **FLOATING
C236 XOR2X1_4/Y 0 24.514923f **FLOATING
C237 NOR2X1_3/Y 0 12.61026f **FLOATING
C238 INVX2_121/Y 0 11.28708f **FLOATING
C239 INVX2_22/Y 0 53.226677f **FLOATING
C240 OAI21X1_92/A 0 13.27953f **FLOATING
C241 INVX2_20/Y 0 8.322119f **FLOATING
C242 player_bullet_coord_x[1] 0 88.67204f **FLOATING
C243 OR2X1_13/A 0 11.680831f **FLOATING
C244 invader_bullet_coord_x[3] 0 56.52086f **FLOATING
C245 INVX2_118/A 0 12.899701f **FLOATING
C246 INVX2_94/Y 0 20.1039f **FLOATING
C247 OR2X1_16/A 0 12.528779f **FLOATING
C248 NOR2X1_28/Y 0 11.99496f **FLOATING
C249 OR2X1_4/A 0 9.20499f **FLOATING
C250 OAI21X1_115/Y 0 9.760681f **FLOATING
C251 INVX2_12/Y 0 25.24752f **FLOATING
C252 AND2X2_1/Y 0 9.066091f **FLOATING
C253 NAND2X1_0/A 0 8.32056f **FLOATING
C254 INVX2_6/Y 0 24.936722f **FLOATING
C255 NOR2X1_4/B 0 9.31638f **FLOATING
C256 NOR2X1_27/B 0 8.643539f **FLOATING
C257 invader_bullet_display 0 26.91099f **FLOATING
C258 INVX2_173/Y 0 19.29678f **FLOATING
C259 OAI21X1_46/C 0 11.244331f **FLOATING
C260 OAI21X1_32/C 0 8.463301f **FLOATING
C261 INVX2_119/Y 0 9.136439f **FLOATING
C262 AOI22X1_11/C 0 8.17737f **FLOATING
C263 player_bullet_coord_y[1] 0 59.203403f **FLOATING
C264 NOR2X1_23/B 0 16.59897f **FLOATING
C265 INVX2_9/A 0 11.97561f **FLOATING
C266 player_bullet_coord_x[2] 0 71.33663f **FLOATING
C267 INVX2_23/Y 0 41.30216f **FLOATING
C268 OAI21X1_47/Y 0 11.17446f **FLOATING
C269 AOI22X1_15/Y 0 10.123441f **FLOATING
C270 AOI21X1_0/B 0 14.06988f **FLOATING
C271 INVX2_3/Y 0 17.24352f **FLOATING
C272 NAND2X1_1/Y 0 37.41441f **FLOATING
C273 HAX1_13/YS 0 19.31625f **FLOATING
C274 OAI21X1_40/Y 0 10.564621f **FLOATING
C275 BUFX2_6/Y 0 0.185419p **FLOATING
C276 AOI21X1_0/C 0 12.354839f **FLOATING
C277 INVX2_117/A 0 13.816979f **FLOATING
C278 INVX2_78/A 0 8.58066f **FLOATING
C279 OAI21X1_39/B 0 14.247299f **FLOATING
C280 OAI21X1_37/C 0 10.894051f **FLOATING
C281 INVX2_34/A 0 12.55173f **FLOATING
C282 HAX1_7/B 0 13.1451f **FLOATING
C283 AOI22X1_3/Y 0 9.80994f **FLOATING
C284 invader_1_coord_y[0] 0 73.42055f **FLOATING
C285 OAI21X1_45/Y 0 10.383f **FLOATING
C286 OAI22X1_8/D 0 55.428635f **FLOATING
C287 INVX2_105/Y 0 12.22008f **FLOATING
C288 OAI21X1_36/Y 0 8.74122f **FLOATING
C289 AOI22X1_17/Y 0 10.88124f **FLOATING
C290 BUFX2_5/Y 0 0.194842p **FLOATING
C291 invader_1_coord_y[2] 0 44.793743f **FLOATING
C292 INVX2_8/Y 0 10.380541f **FLOATING
C293 XNOR2X1_6/B 0 22.266966f **FLOATING
C294 INVX2_51/Y 0 8.357819f **FLOATING
C295 OAI22X1_1/Y 0 10.151999f **FLOATING
C296 INVX2_73/Y 0 7.8375f **FLOATING
C297 AND2X2_10/Y 0 11.96386f **FLOATING
C298 OAI21X1_25/Y 0 21.504599f **FLOATING
C299 HAX1_16/B 0 14.337899f **FLOATING
C300 AOI21X1_8/Y 0 13.275928f **FLOATING
C301 invader_2_coord_x[3] 0 63.321613f **FLOATING
C302 XNOR2X1_6/A 0 36.655647f **FLOATING
C303 AOI22X1_60/C 0 11.09217f **FLOATING
C304 NAND3X1_4/Y 0 11.645969f **FLOATING
C305 AND2X2_7/A 0 12.980128f **FLOATING
C306 INVX2_50/Y 0 23.38866f **FLOATING
C307 INVX2_148/A 0 30.349232f **FLOATING
C308 INVX2_37/Y 0 17.78298f **FLOATING
C309 INVX2_75/Y 0 13.342681f **FLOATING
C310 OAI21X1_5/C 0 11.3043f **FLOATING
C311 AND2X2_7/Y 0 9.517349f **FLOATING
C312 INVX2_44/Y 0 32.39658f **FLOATING
C313 INVX2_50/A 0 8.85645f **FLOATING
C314 invader_2_coord_x[0] 0 66.11471f **FLOATING
C315 OAI21X1_58/C 0 12.727711f **FLOATING
C316 NAND2X1_17/Y 0 9.49494f **FLOATING
C317 NOR2X1_6/Y 0 16.08846f **FLOATING
C318 INVX2_46/Y 0 9.809461f **FLOATING
C319 AND2X2_7/B 0 14.743773f **FLOATING
C320 XNOR2X1_5/B 0 19.427698f **FLOATING
C321 NAND2X1_36/A 0 9.87648f **FLOATING
C322 INVX2_36/Y 0 14.274389f **FLOATING
C323 NAND3X1_3/Y 0 10.711651f **FLOATING
C324 NAND3X1_8/Y 0 9.88605f **FLOATING
C325 AOI21X1_8/B 0 9.557461f **FLOATING
C326 NOR2X1_7/A 0 14.484872f **FLOATING
C327 OAI21X1_63/Y 0 9.910621f **FLOATING
C328 INVX2_41/Y 0 14.169841f **FLOATING
C329 INVX2_99/A 0 21.924839f **FLOATING
C330 invader_2_coord_x[1] 0 51.803562f **FLOATING
C331 INVX2_80/A 0 14.354791f **FLOATING
C332 AOI22X1_1/Y 0 10.76598f **FLOATING
C333 AND2X2_8/Y 0 21.387962f **FLOATING
C334 OAI21X1_59/A 0 13.88502f **FLOATING
C335 XOR2X1_15/Y 0 16.533602f **FLOATING
C336 INVX2_99/Y 0 17.17443f **FLOATING
C337 OAI21X1_60/Y 0 11.989261f **FLOATING
C338 INVX2_47/A 0 12.704791f **FLOATING
C339 OAI21X1_4/B 0 26.232838f **FLOATING
C340 NOR2X1_29/B 0 13.57728f **FLOATING
C341 INVX2_29/Y 0 25.967216f **FLOATING
C342 OAI21X1_24/Y 0 9.313141f **FLOATING
C343 OAI22X1_7/B 0 32.598915f **FLOATING
C344 INVX2_148/Y 0 9.54114f **FLOATING
C345 NOR2X1_11/A 0 18.085743f **FLOATING
C346 NOR2X1_31/Y 0 22.64504f **FLOATING
C347 NAND3X1_6/Y 0 10.582049f **FLOATING
C348 invader_1_display 0 88.06335f **FLOATING
C349 NAND3X1_6/A 0 12.815761f **FLOATING
C350 OAI22X1_9/D 0 9.92517f **FLOATING
C351 OAI21X1_133/Y 0 10.439219f **FLOATING
C352 OAI22X1_9/Y 0 9.793499f **FLOATING
C353 INVX2_146/A 0 31.340876f **FLOATING
C354 OAI22X1_9/C 0 13.66164f **FLOATING
C355 XOR2X1_17/A 0 15.25491f **FLOATING
C356 AOI22X1_4/D 0 10.38684f **FLOATING
C357 OAI22X1_4/Y 0 10.82628f **FLOATING
C358 INVX2_62/A 0 20.121634f **FLOATING
C359 INVX2_67/A 0 9.348961f **FLOATING
C360 INVX2_112/A 0 15.084961f **FLOATING
C361 INVX2_32/A 0 15.440609f **FLOATING
C362 INVX2_112/Y 0 9.087541f **FLOATING
C363 INVX2_67/Y 0 11.32026f **FLOATING
C364 OAI21X1_153/Y 0 10.13652f **FLOATING
C365 OAI22X1_2/Y 0 8.993279f **FLOATING
C366 AOI22X1_4/A 0 10.16385f **FLOATING
C367 INVX2_66/Y 0 13.413121f **FLOATING
C368 XNOR2X1_2/Y 0 18.965698f **FLOATING
C369 INVX2_135/A 0 13.519109f **FLOATING
C370 NOR2X1_57/B 0 13.972261f **FLOATING
C371 XOR2X1_18/Y 0 16.468952f **FLOATING
C372 HAX1_9/B 0 12.4491f **FLOATING
C373 NOR2X1_57/Y 0 9.45822f **FLOATING
C374 INVX2_156/A 0 9.181859f **FLOATING
C375 NOR2X1_57/A 0 10.51278f **FLOATING
C376 OAI21X1_87/Y 0 9.7242f **FLOATING
C377 OAI21X1_55/Y 0 11.28834f **FLOATING
C378 INVX2_65/A 0 15.50106f **FLOATING
C379 invader_1_coord_x[3] 0 90.25965f **FLOATING
C380 HAX1_9/YS 0 14.802841f **FLOATING
C381 OAI21X1_57/C 0 13.641029f **FLOATING
C382 invader_1_coord_x[2] 0 55.931595f **FLOATING
C383 INVX2_28/A 0 21.502232f **FLOATING
C384 XNOR2X1_7/B 0 20.391958f **FLOATING
C385 OAI21X1_57/Y 0 19.34388f **FLOATING
C386 AND2X2_13/Y 0 18.93531f **FLOATING
C387 INVX2_27/A 0 27.658226f **FLOATING
C388 OAI21X1_70/Y 0 13.666861f **FLOATING
C389 OAI21X1_76/Y 0 11.940811f **FLOATING
C390 OAI21X1_72/C 0 9.997739f **FLOATING
C391 AND2X2_12/Y 0 20.031149f **FLOATING
C392 NOR2X1_33/Y 0 10.405499f **FLOATING
C393 INVX2_58/Y 0 9.91842f **FLOATING
C394 AND2X2_14/Y 0 13.397401f **FLOATING
C395 XNOR2X1_7/Y 0 10.285411f **FLOATING
C396 OAI22X1_5/Y 0 12.019081f **FLOATING
C397 OAI21X1_75/Y 0 11.977859f **FLOATING
C398 NOR2X1_47/Y 0 13.382519f **FLOATING
C399 INVX2_122/A 0 10.261559f **FLOATING
C400 OAI21X1_35/C 0 9.979469f **FLOATING
C401 NAND2X1_52/A 0 8.11314f **FLOATING
C402 OR2X1_14/A 0 9.205499f **FLOATING
C403 NAND3X1_42/Y 0 8.964451f **FLOATING
C404 OR2X1_4/B 0 13.676519f **FLOATING
C405 OAI21X1_34/Y 0 9.22416f **FLOATING
C406 INVX2_122/Y 0 11.166061f **FLOATING
C407 AOI22X1_14/A 0 13.794629f **FLOATING
C408 OR2X1_5/B 0 10.367101f **FLOATING
C409 INVX2_105/A 0 9.18906f **FLOATING
C410 NAND2X1_53/A 0 8.11314f **FLOATING
C411 INVX2_164/A 0 12.831f **FLOATING
C412 HAX1_3/YS 0 22.193127f **FLOATING
C413 INVX2_163/A 0 9.18861f **FLOATING
C414 BUFX2_3/Y 0 0.1719p **FLOATING
C415 NOR2X1_48/Y 0 10.60644f **FLOATING
C416 INVX2_131/A 0 19.627317f **FLOATING
C417 NOR2X1_52/Y 0 11.226541f **FLOATING
C418 INVX2_95/Y 0 11.59194f **FLOATING
C419 NOR2X1_49/B 0 7.627141f **FLOATING
C420 NOR2X1_50/Y 0 9.37632f **FLOATING
C421 INVX2_96/A 0 23.43477f **FLOATING
C422 INVX2_98/Y 0 28.706848f **FLOATING
C423 INVX2_97/A 0 33.194756f **FLOATING
C424 AOI22X1_42/B 0 11.15184f **FLOATING
C425 NAND2X1_54/Y 0 8.28744f **FLOATING
C426 HAX1_4/B 0 12.551042f **FLOATING
C427 OR2X1_5/Y 0 11.251919f **FLOATING
C428 OR2X1_4/Y 0 10.923599f **FLOATING
C429 NAND2X1_57/B 0 10.57542f **FLOATING
C430 INVX2_118/Y 0 7.911419f **FLOATING
C431 XNOR2X1_4/Y 0 13.03593f **FLOATING
C432 AOI22X1_46/Y 0 10.40442f **FLOATING
C433 HAX1_1/YS 0 21.57531f **FLOATING
C434 NAND2X1_73/B 0 14.261941f **FLOATING
C435 OR2X1_5/A 0 16.820822f **FLOATING
C436 AOI22X1_16/A 0 8.10789f **FLOATING
C437 INVX2_8/A 0 13.663532f **FLOATING
C438 AOI21X1_30/B 0 9.395339f **FLOATING
C439 NAND2X1_71/A 0 15.550201f **FLOATING
C440 invader_bullet_coord_x[0] 0 27.784847f **FLOATING
C441 NAND2X1_73/Y 0 8.689439f **FLOATING
C442 NOR2X1_56/B 0 13.17696f **FLOATING
C443 INVX2_106/Y 0 19.755657f **FLOATING
C444 NOR2X1_45/B 0 7.80714f **FLOATING
C445 OR2X1_17/A 0 87.93371f **FLOATING
C446 XOR2X1_2/A 0 13.406342f **FLOATING
C447 AOI22X1_8/C 0 9.56937f **FLOATING
C448 OR2X1_15/Y 0 7.25028f **FLOATING
C449 NAND2X1_55/Y 0 23.536125f **FLOATING
C450 AND2X2_19/Y 0 24.323729f **FLOATING
C451 NOR2X1_51/Y 0 11.488501f **FLOATING
C452 OR2X1_12/Y 0 8.596441f **FLOATING
C453 NOR2X1_42/A 0 9.090779f **FLOATING
C454 NOR2X1_20/B 0 20.452768f **FLOATING
C455 AND2X2_2/Y 0 9.989429f **FLOATING
C456 AOI22X1_8/Y 0 7.4109f **FLOATING
C457 OAI21X1_94/Y 0 10.27692f **FLOATING
C458 AOI22X1_9/Y 0 12.211441f **FLOATING
C459 INVX2_93/Y 0 30.268116f **FLOATING
C460 INVX2_87/A 0 21.37041f **FLOATING
C461 INVX2_86/Y 0 8.037089f **FLOATING
C462 INVX2_134/Y 0 7.698599f **FLOATING
C463 OR2X1_16/B 0 9.882302f **FLOATING
C464 OAI21X1_29/Y 0 10.541821f **FLOATING
C465 OAI21X1_41/Y 0 9.962461f **FLOATING
C466 OAI21X1_43/Y 0 10.06374f **FLOATING
C467 OAI21X1_40/C 0 11.26125f **FLOATING
C468 OAI21X1_44/Y 0 11.144521f **FLOATING
C469 XOR2X1_7/Y 0 9.610139f **FLOATING
C470 OAI21X1_41/C 0 16.071331f **FLOATING
C471 shield_coord_x[1] 0 67.11546f **FLOATING
C472 INVX2_92/Y 0 22.900383f **FLOATING
C473 INVX2_141/A 0 13.408259f **FLOATING
C474 NOR2X1_56/A 0 10.801141f **FLOATING
C475 INVX2_109/A 0 10.8234f **FLOATING
C476 XOR2X1_13/Y 0 10.278661f **FLOATING
C477 XOR2X1_8/Y 0 9.541261f **FLOATING
C478 OAI22X1_7/Y 0 16.625101f **FLOATING
C479 INVX2_64/Y 0 51.727436f **FLOATING
C480 OAI22X1_6/Y 0 10.05024f **FLOATING
C481 OAI22X1_8/Y 0 14.8986f **FLOATING
C482 INVX2_140/A 0 11.118899f **FLOATING
C483 OAI21X1_135/Y 0 8.811421f **FLOATING
C484 INVX2_113/A 0 13.98948f **FLOATING
C485 NAND2X1_76/A 0 13.143419f **FLOATING
C486 NAND2X1_78/B 0 11.70366f **FLOATING
C487 OAI21X1_136/Y 0 15.0912f **FLOATING
C488 XOR2X1_20/Y 0 19.23348f **FLOATING
C489 NAND2X1_79/Y 0 24.12195f **FLOATING
C490 INVX2_107/A 0 13.21524f **FLOATING
C491 XOR2X1_13/A 0 18.68049f **FLOATING
C492 OAI22X1_9/B 0 18.470581f **FLOATING
C493 XOR2X1_7/A 0 19.323244f **FLOATING
C494 NAND2X1_31/Y 0 7.703401f **FLOATING
C495 INVX2_115/A 0 9.141539f **FLOATING
C496 AND2X2_16/B 0 8.229449f **FLOATING
C497 NOR2X1_41/B 0 11.839682f **FLOATING
C498 INVX2_134/A 0 14.43597f **FLOATING
C499 INVX2_89/Y 0 15.009841f **FLOATING
C500 INVX2_132/A 0 11.214061f **FLOATING
C501 AND2X2_17/Y 0 18.237633f **FLOATING
C502 OR2X1_11/A 0 12.452401f **FLOATING
C503 INVX2_171/Y 0 10.81518f **FLOATING
C504 INVX2_171/A 0 9.4377f **FLOATING
C505 INVX2_133/Y 0 25.530407f **FLOATING
C506 AND2X2_16/Y 0 9.34083f **FLOATING
C507 OAI21X1_31/Y 0 10.886459f **FLOATING
C508 NAND3X1_41/A 0 11.21664f **FLOATING
C509 OAI21X1_28/Y 0 12.451681f **FLOATING
C510 NOR2X1_28/A 0 34.79553f **FLOATING
C511 INVX2_88/A 0 31.170988f **FLOATING
C512 OAI21X1_96/C 0 13.547551f **FLOATING
C513 NOR2X1_14/Y 0 10.63854f **FLOATING
C514 XOR2X1_0/Y 0 8.7705f **FLOATING
C515 XOR2X1_0/A 0 17.60706f **FLOATING
C516 XOR2X1_11/Y 0 8.138941f **FLOATING
C517 INVX2_168/Y 0 47.083897f **FLOATING
C518 OAI21X1_96/Y 0 12.329819f **FLOATING
C519 OAI21X1_32/Y 0 11.843101f **FLOATING
C520 INVX2_21/Y 0 11.223061f **FLOATING
C521 player_bullet_coord_x[0] 0 65.05978f **FLOATING
C522 NOR2X1_26/Y 0 13.665899f **FLOATING
C523 INVX2_142/A 0 9.218821f **FLOATING
C524 OAI22X1_7/C 0 43.699966f **FLOATING
C525 INVX2_101/A 0 15.8028f **FLOATING
C526 NAND2X1_68/A 0 11.345699f **FLOATING
C527 XOR2X1_16/Y 0 11.085269f **FLOATING
C528 INVX2_110/Y 0 25.06752f **FLOATING
C529 XNOR2X1_8/B 0 20.019716f **FLOATING
C530 XNOR2X1_8/Y 0 10.69155f **FLOATING
C531 XOR2X1_5/Y 0 8.28774f **FLOATING
C532 invader_1_coord_x[1] 0 62.681324f **FLOATING
C533 OAI21X1_145/Y 0 8.39502f **FLOATING
C534 NOR2X1_5/A 0 16.835253f **FLOATING
C535 OAI21X1_3/Y 0 8.5443f **FLOATING
C536 INVX2_52/Y 0 8.634959f **FLOATING
C537 OAI21X1_148/Y 0 10.51965f **FLOATING
C538 INVX2_55/Y 0 39.761414f **FLOATING
C539 OAI21X1_18/Y 0 10.265339f **FLOATING
C540 NOR2X1_9/Y 0 17.77182f **FLOATING
C541 INVX2_63/Y 0 24.46614f **FLOATING
C542 XOR2X1_5/A 0 15.341761f **FLOATING
C543 OAI22X1_0/Y 0 8.993279f **FLOATING
C544 OAI21X1_5/Y 0 13.08681f **FLOATING
C545 OAI21X1_17/Y 0 8.7594f **FLOATING
C546 player_bullet_coord_x[3] 0 52.36032f **FLOATING
C547 OAI21X1_50/Y 0 13.633861f **FLOATING
C548 NAND2X1_5/B 0 9.36252f **FLOATING
C549 INVX2_11/Y 0 12.92052f **FLOATING
C550 BUFX2_4/A 0 14.609133f **FLOATING
C551 clkb 0 31.043022f **FLOATING
C552 INVX2_167/A 0 10.3152f **FLOATING
C553 AND2X2_8/A 0 70.610466f **FLOATING
C554 invader_bullet_coord_y[0] 0 71.819885f **FLOATING
C555 BUFX2_7/A 0 30.400137f **FLOATING
C556 NOR2X1_2/A 0 7.783679f **FLOATING
C557 INVX2_13/A 0 14.118929f **FLOATING
C558 NAND2X1_0/B 0 9.436171f **FLOATING
C559 NOR2X1_2/Y 0 8.834939f **FLOATING
C560 INVX2_143/A 0 9.32625f **FLOATING
C561 INVX2_143/Y 0 10.81518f **FLOATING
C562 INVX2_18/Y 0 34.919857f **FLOATING
C563 AOI21X1_4/Y 0 9.274289f **FLOATING
C564 OR2X1_0/B 0 14.41818f **FLOATING
C565 OR2X1_0/Y 0 7.46781f **FLOATING
C566 INVX2_49/Y 0 11.563801f **FLOATING
C567 OR2X1_0/A 0 8.46306f **FLOATING
C568 OAI21X1_2/C 0 9.695251f **FLOATING
C569 OAI21X1_1/C 0 11.416019f **FLOATING
C570 HAX1_16/YS 0 23.417728f **FLOATING
C571 INVX2_45/Y 0 10.133941f **FLOATING
C572 AOI22X1_0/A 0 9.95265f **FLOATING
C573 AND2X2_15/A 0 12.488851f **FLOATING
C574 INVX2_62/Y 0 8.771879f **FLOATING
C575 invader_1_coord_x[0] 0 67.214066f **FLOATING
C576 NOR2X1_9/A 0 14.42211f **FLOATING
C577 INVX2_68/A 0 8.77461f **FLOATING
C578 INVX2_68/Y 0 24.264458f **FLOATING
C579 OR2X1_2/Y 0 10.32501f **FLOATING
C580 INVX2_47/Y 0 13.27332f **FLOATING
C581 INVX2_49/A 0 9.38046f **FLOATING
C582 HAX1_15/B 0 12.631501f **FLOATING
C583 OR2X1_2/B 0 12.540059f **FLOATING
C584 OAI21X1_80/Y 0 12.35808f **FLOATING
C585 INVX2_19/Y 0 32.17113f **FLOATING
C586 NAND3X1_5/Y 0 8.964451f **FLOATING
C587 HAX1_10/YS 0 21.660149f **FLOATING
C588 OAI21X1_53/C 0 18.665442f **FLOATING
C589 INVX2_48/A 0 22.24635f **FLOATING
C590 INVX2_117/Y 0 10.742039f **FLOATING
C591 NOR2X1_1/A 0 8.53266f **FLOATING
C592 NAND2X1_36/Y 0 11.879431f **FLOATING
C593 NAND2X1_36/B 0 7.64082f **FLOATING
C594 INVX2_46/A 0 17.1682f **FLOATING
C595 OAI21X1_53/Y 0 11.576161f **FLOATING
C596 OAI21X1_77/Y 0 13.400459f **FLOATING
C597 AND2X2_11/Y 0 10.71975f **FLOATING
C598 INVX2_155/Y 0 7.221059f **FLOATING
C599 OAI21X1_79/Y 0 17.293982f **FLOATING
C600 INVX2_30/Y 0 27.999714f **FLOATING
C601 OR2X1_8/Y 0 10.73922f **FLOATING
C602 AND2X2_11/A 0 11.892241f **FLOATING
C603 OAI21X1_86/Y 0 14.867639f **FLOATING
C604 AND2X2_9/B 0 43.40273f **FLOATING
C605 INVX2_149/A 0 50.140247f **FLOATING
C606 INVX2_33/Y 0 16.896996f **FLOATING
C607 OAI21X1_65/Y 0 10.568221f **FLOATING
C608 NAND3X1_48/B 0 19.524298f **FLOATING
C609 NAND2X1_0/Y 0 11.358541f **FLOATING
C610 INVX2_166/A 0 23.720007f **FLOATING
C611 INVX2_152/Y 0 9.59184f **FLOATING
C612 LATCH_2/D 0 8.197591f **FLOATING
C613 OAI21X1_123/Y 0 13.568101f **FLOATING
C614 NOR2X1_60/A 0 17.502842f **FLOATING
C615 LATCH_1/D 0 8.127991f **FLOATING
C616 INVX2_2/A 0 40.294495f **FLOATING
C617 OR2X1_15/A 0 0.165775p **FLOATING
C618 INVX2_123/A 0 11.809833f **FLOATING
C619 INVX2_2/Y 0 37.38836f **FLOATING
C620 INVX2_10/A 0 12.75123f **FLOATING
C621 OAI21X1_63/C 0 13.30701f **FLOATING
C622 OR2X1_1/Y 0 10.825798f **FLOATING
C623 OAI22X1_8/A 0 47.2737f **FLOATING
C624 INVX2_144/A 0 13.71173f **FLOATING
C625 OR2X1_20/Y 0 11.452109f **FLOATING
C626 INVX2_185/A 0 17.291727f **FLOATING
C627 OR2X1_1/A 0 11.682361f **FLOATING
C628 OR2X1_7/B 0 12.014999f **FLOATING
C629 invader_2_display 0 41.589943f **FLOATING
C630 OR2X1_1/B 0 10.39782f **FLOATING
C631 HAX1_12/B 0 12.3651f **FLOATING
C632 NOR2X1_27/Y 0 11.242439f **FLOATING
C633 INVX2_170/A 0 8.11314f **FLOATING
C634 INVX2_150/A 0 11.53275f **FLOATING
C635 BUFX2_2/Y 0 0.162597p **FLOATING
C636 NAND2X1_64/B 0 10.681979f **FLOATING
C637 OAI21X1_130/Y 0 8.742901f **FLOATING
C638 player_shoot_input 0 13.00203f **FLOATING
C639 INVX2_151/Y 0 17.176859f **FLOATING
C640 NOR2X1_55/A 0 16.766888f **FLOATING
C641 LATCH_2/CLK 0 30.376705f **FLOATING
C642 LATCH_0/Q 0 10.039618f **FLOATING
C643 LATCH_0/D 0 10.05939f **FLOATING
C644 XOR2X1_10/Y 0 11.10003f **FLOATING
C645 INVX2_17/A 0 18.10299f **FLOATING
C646 INVX2_90/Y 0 30.345375f **FLOATING
C647 NOR2X1_3/A 0 7.65936f **FLOATING
C648 INVX2_17/Y 0 7.95444f **FLOATING
C649 INVX2_24/A 0 11.791739f **FLOATING
C650 INVX2_16/A 0 26.527128f **FLOATING
C651 INVX2_14/Y 0 12.86292f **FLOATING
C652 INVX2_39/A 0 10.57125f **FLOATING
C653 OAI21X1_7/Y 0 9.207541f **FLOATING
C654 INVX2_31/Y 0 23.80818f **FLOATING
C655 invader_2_coord_y[3] 0 59.03627f **FLOATING
C656 NOR2X1_31/A 0 16.939383f **FLOATING
C657 OAI21X1_61/A 0 11.69997f **FLOATING
C658 invader_2_coord_y[2] 0 55.86482f **FLOATING
C659 invader_2_coord_y[1] 0 65.45276f **FLOATING
C660 AOI22X1_2/A 0 10.16625f **FLOATING
C661 OAI21X1_8/C 0 10.791869f **FLOATING
C662 OAI21X1_49/B 0 8.652f **FLOATING
C663 AND2X2_20/Y 0 11.502931f **FLOATING
C664 player_bullet_coord_y[2] 0 57.932827f **FLOATING
C665 NAND2X1_3/A 0 10.74456f **FLOATING
C666 INVX2_39/Y 0 14.2383f **FLOATING
C667 INVX2_35/A 0 14.536771f **FLOATING
C668 INVX2_83/A 0 42.85111f **FLOATING
C669 AND2X2_0/B 0 10.70835f **FLOATING
C670 NOR2X1_24/Y 0 12.014071f **FLOATING
C671 AND2X2_0/Y 0 10.13481f **FLOATING
C672 player_bullet_display 0 11.915911f **FLOATING
C673 AOI22X1_7/Y 0 7.75242f **FLOATING
C674 INVX2_72/Y 0 8.702279f **FLOATING
C675 INVX2_15/Y 0 31.262035f **FLOATING
C676 NOR2X1_23/Y 0 8.76642f **FLOATING
C677 NAND2X1_2/Y 0 9.70668f **FLOATING
C678 BUFX2_7/Y 0 0.150829p **FLOATING
C679 INVX2_43/Y 0 7.648979f **FLOATING
C680 INVX2_41/A 0 9.33957f **FLOATING
C681 INVX2_37/A 0 9.105421f **FLOATING
C682 INVX2_147/Y 0 8.075519f **FLOATING
C683 OAI21X1_56/C 0 8.964451f **FLOATING
C684 INVX2_26/Y 0 11.06364f **FLOATING
C685 INVX2_138/Y 0 20.237942f **FLOATING
C686 INVX2_26/A 0 28.443386f **FLOATING
C687 OR2X1_20/B 0 15.284911f **FLOATING
C688 NAND3X1_28/Y 0 12.172829f **FLOATING
C689 OAI21X1_81/Y 0 7.01526f **FLOATING
C690 INVX2_30/A 0 15.306121f **FLOATING
C691 OAI21X1_71/B 0 18.935371f **FLOATING
C692 INVX2_53/Y 0 7.90158f **FLOATING
C693 INVX2_53/A 0 20.584044f **FLOATING
C694 OAI21X1_11/Y 0 11.161621f **FLOATING
C695 AOI21X1_8/C 0 8.309999f **FLOATING
C696 OAI22X1_3/Y 0 8.7807f **FLOATING
C697 NAND3X1_3/A 0 11.2248f **FLOATING
C698 HAX1_7/YS 0 11.97381f **FLOATING
C699 player_bullet_coord_y[3] 0 52.69825f **FLOATING
C700 INVX2_77/Y 0 17.29542f **FLOATING
C701 invader_1_coord_y[1] 0 57.64911f **FLOATING
C702 INVX2_75/A 0 9.36918f **FLOATING
C703 NOR2X1_12/Y 0 14.638202f **FLOATING
C704 AOI22X1_6/D 0 16.49646f **FLOATING
C705 AOI22X1_6/A 0 11.25183f **FLOATING
C706 OR2X1_3/A 0 13.57194f **FLOATING
C707 HAX1_6/YS 0 9.88209f **FLOATING
C708 OR2X1_3/B 0 12.1002f **FLOATING
C709 OAI21X1_26/Y 0 9.768301f **FLOATING
C710 OAI21X1_81/A 0 9.17319f **FLOATING
C711 AND2X2_14/B 0 48.52581f **FLOATING
C712 INVX2_61/Y 0 17.7915f **FLOATING
C713 OAI22X1_5/D 0 10.10436f **FLOATING
C714 INVX2_74/Y 0 18.157763f **FLOATING
C715 NAND3X1_35/A 0 11.949809f **FLOATING
C716 AND2X2_15/Y 0 7.948629f **FLOATING
C717 OR2X1_3/Y 0 9.634979f **FLOATING
C718 INVX2_79/A 0 9.666211f **FLOATING
C719 OR2X1_9/B 0 9.13074f **FLOATING
C720 NOR2X1_34/Y 0 25.364294f **FLOATING
C721 OAI21X1_74/Y 0 10.350361f **FLOATING
C722 INVX2_59/A 0 20.318039f **FLOATING
C723 OAI21X1_91/C 0 9.886051f **FLOATING
C724 OAI21X1_91/Y 0 12.203521f **FLOATING
C725 INVX2_82/Y 0 11.4969f **FLOATING
C726 OR2X1_9/A 0 39.960983f **FLOATING
C727 OR2X1_10/Y 0 10.6077f **FLOATING
C728 INVX2_56/A 0 20.81715f **FLOATING
C729 OAI21X1_90/C 0 12.695489f **FLOATING
C730 OAI21X1_91/B 0 23.688633f **FLOATING
C731 OAI21X1_75/C 0 13.655251f **FLOATING
C732 OAI21X1_76/C 0 12.31026f **FLOATING
C733 OAI22X1_5/B 0 40.26837f **FLOATING
C734 INVX2_57/A 0 20.004808f **FLOATING
C735 vdd 0 11.912136p **FLOATING
C736 XNOR2X1_5/a_2_6# 0 6.77121f **FLOATING
C737 XNOR2X1_5/a_12_41# 0 7.905991f **FLOATING
C738 OAI21X1_18/a_2_6# 0 2.78652f **FLOATING
C739 OAI21X1_29/a_2_6# 0 2.78652f **FLOATING
C740 OAI22X1_2/a_2_6# 0 4.25172f **FLOATING
C741 AOI22X1_62/a_2_54# 0 6.66f **FLOATING
C742 AOI22X1_62/C 0 10.71525f **FLOATING
C743 AOI22X1_51/a_2_54# 0 6.66f **FLOATING
C744 AOI22X1_40/a_2_54# 0 6.66f **FLOATING
C745 INVX2_123/Y 0 20.77674f **FLOATING
C746 OAI21X1_74/A 0 12.098131f **FLOATING
C747 AND2X2_4/a_2_6# 0 6.03567f **FLOATING
C748 INVX2_32/Y 0 11.67924f **FLOATING
C749 HAX1_8/a_38_6# 0 2.442f **FLOATING
C750 HAX1_8/YS 0 12.15228f **FLOATING
C751 HAX1_8/a_41_74# 0 5.99325f **FLOATING
C752 HAX1_8/a_2_74# 0 7.65318f **FLOATING
C753 DFFNEGX1_72/a_66_6# 0 6.40992f **FLOATING
C754 DFFNEGX1_72/a_23_6# 0 6.85692f **FLOATING
C755 DFFNEGX1_72/a_34_4# 0 4.93023f **FLOATING
C756 DFFNEGX1_72/a_2_6# 0 9.33504f **FLOATING
C757 DFFNEGX1_83/a_66_6# 0 6.40992f **FLOATING
C758 DFFNEGX1_83/a_23_6# 0 6.85692f **FLOATING
C759 DFFNEGX1_83/a_34_4# 0 4.93023f **FLOATING
C760 DFFNEGX1_83/a_2_6# 0 9.33504f **FLOATING
C761 DFFNEGX1_50/a_66_6# 0 6.40992f **FLOATING
C762 DFFNEGX1_50/a_23_6# 0 6.85692f **FLOATING
C763 DFFNEGX1_50/a_34_4# 0 4.93023f **FLOATING
C764 DFFNEGX1_50/a_2_6# 0 9.33504f **FLOATING
C765 OR2X1_9/Y 0 11.096431f **FLOATING
C766 DFFNEGX1_61/a_66_6# 0 6.40992f **FLOATING
C767 DFFNEGX1_61/a_23_6# 0 6.85692f **FLOATING
C768 DFFNEGX1_61/a_34_4# 0 4.93023f **FLOATING
C769 DFFNEGX1_61/a_2_6# 0 9.33504f **FLOATING
C770 XNOR2X1_4/a_2_6# 0 6.77121f **FLOATING
C771 XNOR2X1_4/a_12_41# 0 7.905991f **FLOATING
C772 XNOR2X1_6/Y 0 9.45429f **FLOATING
C773 OAI21X1_39/a_2_6# 0 2.78652f **FLOATING
C774 OAI21X1_28/a_2_6# 0 2.78652f **FLOATING
C775 OAI21X1_17/a_2_6# 0 2.78652f **FLOATING
C776 INVX2_70/Y 0 6.65643f **FLOATING
C777 INVX2_76/Y 0 5.717219f **FLOATING
C778 INVX2_54/Y 0 5.92962f **FLOATING
C779 INVX2_54/A 0 15.71004f **FLOATING
C780 OAI22X1_1/a_2_6# 0 4.25172f **FLOATING
C781 AOI22X1_61/a_2_54# 0 6.66f **FLOATING
C782 AOI22X1_50/a_2_54# 0 6.66f **FLOATING
C783 NOR2X1_55/B 0 6.17448f **FLOATING
C784 INVX2_136/Y 0 17.47224f **FLOATING
C785 NAND2X1_30/Y 0 6.66258f **FLOATING
C786 NOR2X1_19/Y 0 11.402581f **FLOATING
C787 AND2X2_3/a_2_6# 0 6.03567f **FLOATING
C788 HAX1_7/a_38_6# 0 2.442f **FLOATING
C789 HAX1_7/a_41_74# 0 5.99325f **FLOATING
C790 HAX1_7/a_2_74# 0 7.65318f **FLOATING
C791 DFFNEGX1_82/a_66_6# 0 6.40992f **FLOATING
C792 DFFNEGX1_82/a_23_6# 0 6.85692f **FLOATING
C793 DFFNEGX1_82/a_34_4# 0 4.93023f **FLOATING
C794 DFFNEGX1_82/a_2_6# 0 9.33504f **FLOATING
C795 NOR2X1_59/Y 0 14.327041f **FLOATING
C796 DFFNEGX1_71/a_66_6# 0 6.40992f **FLOATING
C797 DFFNEGX1_71/a_23_6# 0 6.85692f **FLOATING
C798 DFFNEGX1_71/a_34_4# 0 4.93023f **FLOATING
C799 DFFNEGX1_71/a_2_6# 0 9.33504f **FLOATING
C800 DFFNEGX1_60/a_66_6# 0 6.40992f **FLOATING
C801 shield_coord_y[2] 0 30.54269f **FLOATING
C802 DFFNEGX1_60/a_23_6# 0 6.85692f **FLOATING
C803 DFFNEGX1_60/a_34_4# 0 4.93023f **FLOATING
C804 DFFNEGX1_60/a_2_6# 0 9.33504f **FLOATING
C805 OAI21X1_97/Y 0 12.161761f **FLOATING
C806 INVX2_108/Y 0 9.79758f **FLOATING
C807 XNOR2X1_3/a_2_6# 0 6.77121f **FLOATING
C808 XNOR2X1_3/a_12_41# 0 7.905991f **FLOATING
C809 AND2X2_19/a_2_6# 0 6.03567f **FLOATING
C810 OAI21X1_27/a_2_6# 0 2.78652f **FLOATING
C811 OAI21X1_38/a_2_6# 0 2.78652f **FLOATING
C812 NAND2X1_9/Y 0 6.86169f **FLOATING
C813 OAI21X1_49/a_2_6# 0 2.78652f **FLOATING
C814 INVX2_139/A 0 6.0849f **FLOATING
C815 OAI21X1_16/a_2_6# 0 2.78652f **FLOATING
C816 INVX2_42/Y 0 5.61768f **FLOATING
C817 OAI21X1_85/Y 0 11.144521f **FLOATING
C818 OAI22X1_0/a_2_6# 0 4.25172f **FLOATING
C819 AOI22X1_60/a_2_54# 0 6.66f **FLOATING
C820 NAND2X1_51/Y 0 8.252641f **FLOATING
C821 AND2X2_9/A 0 11.690761f **FLOATING
C822 NAND3X1_29/Y 0 12.645569f **FLOATING
C823 OAI21X1_61/Y 0 13.95066f **FLOATING
C824 AND2X2_2/a_2_6# 0 6.03567f **FLOATING
C825 HAX1_6/a_38_6# 0 2.442f **FLOATING
C826 HAX1_6/a_41_74# 0 5.99325f **FLOATING
C827 HAX1_6/a_2_74# 0 7.65318f **FLOATING
C828 HAX1_6/B 0 18.25551f **FLOATING
C829 invader_1_coord_y[3] 0 77.240234f **FLOATING
C830 DFFNEGX1_81/a_66_6# 0 6.40992f **FLOATING
C831 DFFNEGX1_81/a_23_6# 0 6.85692f **FLOATING
C832 DFFNEGX1_81/a_34_4# 0 4.93023f **FLOATING
C833 DFFNEGX1_81/a_2_6# 0 9.33504f **FLOATING
C834 DFFNEGX1_70/a_66_6# 0 6.40992f **FLOATING
C835 DFFNEGX1_70/a_23_6# 0 6.85692f **FLOATING
C836 DFFNEGX1_70/a_34_4# 0 4.93023f **FLOATING
C837 DFFNEGX1_70/a_2_6# 0 9.33504f **FLOATING
C838 INVX2_120/Y 0 7.221059f **FLOATING
C839 XNOR2X1_2/a_2_6# 0 6.77121f **FLOATING
C840 XNOR2X1_2/a_12_41# 0 7.905991f **FLOATING
C841 NAND2X1_69/A 0 13.235521f **FLOATING
C842 AND2X2_18/a_2_6# 0 6.03567f **FLOATING
C843 OR2X1_19/a_2_54# 0 6.27999f **FLOATING
C844 OAI21X1_59/a_2_6# 0 2.78652f **FLOATING
C845 OAI21X1_59/Y 0 6.0849f **FLOATING
C846 OAI21X1_37/a_2_6# 0 2.78652f **FLOATING
C847 OAI21X1_48/a_2_6# 0 2.78652f **FLOATING
C848 OAI21X1_48/C 0 6.91446f **FLOATING
C849 OAI21X1_15/a_2_6# 0 2.78652f **FLOATING
C850 OAI21X1_26/a_2_6# 0 2.78652f **FLOATING
C851 shield_hp[0] 0 25.293018f **FLOATING
C852 INVX2_5/A 0 15.15306f **FLOATING
C853 NOR2X1_32/B 0 27.048449f **FLOATING
C854 INVX2_165/Y 0 48.372116f **FLOATING
C855 OAI21X1_112/Y 0 11.397661f **FLOATING
C856 NOR2X1_48/A 0 14.576822f **FLOATING
C857 NOR2X1_17/Y 0 10.0185f **FLOATING
C858 INVX2_135/Y 0 21.149239f **FLOATING
C859 AND2X2_1/a_2_6# 0 6.03567f **FLOATING
C860 HAX1_5/a_38_6# 0 2.442f **FLOATING
C861 HAX1_5/a_41_74# 0 5.99325f **FLOATING
C862 HAX1_5/a_2_74# 0 7.65318f **FLOATING
C863 DFFNEGX1_80/a_66_6# 0 6.40992f **FLOATING
C864 DFFNEGX1_80/a_23_6# 0 6.85692f **FLOATING
C865 DFFNEGX1_80/a_34_4# 0 4.93023f **FLOATING
C866 DFFNEGX1_80/a_2_6# 0 9.33504f **FLOATING
C867 INVX2_167/Y 0 12.9315f **FLOATING
C868 DFFNEGX1_91/a_66_6# 0 6.40992f **FLOATING
C869 DFFNEGX1_91/a_23_6# 0 6.85692f **FLOATING
C870 DFFNEGX1_91/a_34_4# 0 4.93023f **FLOATING
C871 DFFNEGX1_91/a_2_6# 0 9.33504f **FLOATING
C872 OAI22X1_4/D 0 23.351097f **FLOATING
C873 OAI22X1_9/A 0 8.541962f **FLOATING
C874 XNOR2X1_1/Y 0 15.356551f **FLOATING
C875 XNOR2X1_1/a_2_6# 0 6.77121f **FLOATING
C876 XNOR2X1_1/a_12_41# 0 7.905991f **FLOATING
C877 BUFX2_4/Y 0 0.208008p **FLOATING
C878 AND2X2_17/a_2_6# 0 6.03567f **FLOATING
C879 OR2X1_18/Y 0 13.617659f **FLOATING
C880 OR2X1_18/a_2_54# 0 6.27999f **FLOATING
C881 OAI21X1_69/a_2_6# 0 2.78652f **FLOATING
C882 OAI21X1_58/a_2_6# 0 2.78652f **FLOATING
C883 OAI21X1_36/a_2_6# 0 2.78652f **FLOATING
C884 OAI21X1_36/C 0 10.37472f **FLOATING
C885 OAI21X1_47/a_2_6# 0 2.78652f **FLOATING
C886 NAND2X1_7/Y 0 6.86169f **FLOATING
C887 OAI21X1_14/a_2_6# 0 2.78652f **FLOATING
C888 OAI21X1_25/a_2_6# 0 2.78652f **FLOATING
C889 INVX2_84/Y 0 5.92962f **FLOATING
C890 INVX2_162/A 0 15.581012f **FLOATING
C891 INVX2_89/A 0 34.592854f **FLOATING
C892 NOR2X1_35/B 0 21.425669f **FLOATING
C893 OAI21X1_97/A 0 29.423435f **FLOATING
C894 AND2X2_0/a_2_6# 0 6.03567f **FLOATING
C895 HAX1_4/a_38_6# 0 2.442f **FLOATING
C896 HAX1_4/a_41_74# 0 5.99325f **FLOATING
C897 HAX1_4/a_2_74# 0 7.65318f **FLOATING
C898 DFFNEGX1_90/a_66_6# 0 6.40992f **FLOATING
C899 DFFNEGX1_90/a_23_6# 0 6.85692f **FLOATING
C900 DFFNEGX1_90/a_34_4# 0 4.93023f **FLOATING
C901 DFFNEGX1_90/a_2_6# 0 9.33504f **FLOATING
C902 XNOR2X1_0/a_2_6# 0 6.77121f **FLOATING
C903 XNOR2X1_0/a_12_41# 0 7.905991f **FLOATING
C904 AND2X2_16/a_2_6# 0 6.03567f **FLOATING
C905 OR2X1_17/a_2_54# 0 6.27999f **FLOATING
C906 OAI21X1_79/a_2_6# 0 2.78652f **FLOATING
C907 OAI21X1_57/a_2_6# 0 2.78652f **FLOATING
C908 OAI21X1_68/a_2_6# 0 2.78652f **FLOATING
C909 OAI21X1_46/a_2_6# 0 2.78652f **FLOATING
C910 OAI21X1_24/a_2_6# 0 2.78652f **FLOATING
C911 OAI21X1_13/a_2_6# 0 2.78652f **FLOATING
C912 INVX2_42/A 0 10.21578f **FLOATING
C913 OAI21X1_35/a_2_6# 0 2.78652f **FLOATING
C914 NOR2X1_16/B 0 8.844299f **FLOATING
C915 OR2X1_19/Y 0 19.0861f **FLOATING
C916 HAX1_3/a_38_6# 0 2.442f **FLOATING
C917 HAX1_3/a_41_74# 0 5.99325f **FLOATING
C918 HAX1_3/a_2_74# 0 7.65318f **FLOATING
C919 AND2X2_15/a_2_6# 0 6.03567f **FLOATING
C920 OR2X1_16/a_2_54# 0 6.27999f **FLOATING
C921 OAI21X1_89/a_2_6# 0 2.78652f **FLOATING
C922 OAI21X1_78/a_2_6# 0 2.78652f **FLOATING
C923 OAI21X1_78/Y 0 12.434701f **FLOATING
C924 OAI21X1_56/a_2_6# 0 2.78652f **FLOATING
C925 OAI21X1_56/Y 0 15.285902f **FLOATING
C926 OAI21X1_67/a_2_6# 0 2.78652f **FLOATING
C927 OAI21X1_23/a_2_6# 0 2.78652f **FLOATING
C928 OAI21X1_12/a_2_6# 0 2.78652f **FLOATING
C929 OAI21X1_45/a_2_6# 0 2.78652f **FLOATING
C930 OAI21X1_34/a_2_6# 0 2.78652f **FLOATING
C931 OAI21X1_34/C 0 8.94963f **FLOATING
C932 INVX2_60/Y 0 5.86302f **FLOATING
C933 INVX2_100/A 0 20.10828f **FLOATING
C934 AOI22X1_40/B 0 12.59994f **FLOATING
C935 AOI21X1_26/Y 0 11.964451f **FLOATING
C936 NOR2X1_25/Y 0 11.360129f **FLOATING
C937 INVX2_16/Y 0 5.96922f **FLOATING
C938 OAI21X1_92/B 0 14.91326f **FLOATING
C939 NOR2X1_37/Y 0 8.243641f **FLOATING
C940 INVX2_0/Y 0 9.16683f **FLOATING
C941 HAX1_2/a_38_6# 0 2.442f **FLOATING
C942 HAX1_2/a_41_74# 0 5.99325f **FLOATING
C943 HAX1_2/a_2_74# 0 7.65318f **FLOATING
C944 AND2X2_14/a_2_6# 0 6.03567f **FLOATING
C945 AND2X2_25/a_2_6# 0 6.03567f **FLOATING
C946 OR2X1_15/a_2_54# 0 6.27999f **FLOATING
C947 OAI21X1_88/a_2_6# 0 2.78652f **FLOATING
C948 OAI21X1_99/a_2_6# 0 2.78652f **FLOATING
C949 OAI21X1_77/a_2_6# 0 2.78652f **FLOATING
C950 OAI21X1_55/a_2_6# 0 2.78652f **FLOATING
C951 OAI21X1_66/a_2_6# 0 2.78652f **FLOATING
C952 OAI21X1_66/Y 0 11.949481f **FLOATING
C953 OAI21X1_44/a_2_6# 0 2.78652f **FLOATING
C954 OAI21X1_22/a_2_6# 0 2.78652f **FLOATING
C955 NAND3X1_7/Y 0 11.30787f **FLOATING
C956 OAI21X1_33/a_2_6# 0 2.78652f **FLOATING
C957 OAI21X1_33/Y 0 8.48316f **FLOATING
C958 OAI21X1_11/a_2_6# 0 2.78652f **FLOATING
C959 INVX2_81/Y 0 7.641959f **FLOATING
C960 NOR2X1_51/A 0 10.82586f **FLOATING
C961 INVX2_161/A 0 23.146166f **FLOATING
C962 LATCH_2/a_23_6# 0 6.09987f **FLOATING
C963 LATCH_2/a_2_6# 0 6.82959f **FLOATING
C964 XOR2X1_2/Y 0 8.971381f **FLOATING
C965 INVX2_82/A 0 16.531832f **FLOATING
C966 HAX1_1/a_38_6# 0 2.442f **FLOATING
C967 HAX1_0/B 0 12.34488f **FLOATING
C968 HAX1_1/a_41_74# 0 5.99325f **FLOATING
C969 HAX1_1/a_2_74# 0 7.65318f **FLOATING
C970 HAX1_1/B 0 13.65552f **FLOATING
C971 AND2X2_24/a_2_6# 0 6.03567f **FLOATING
C972 AND2X2_13/a_2_6# 0 6.03567f **FLOATING
C973 OR2X1_14/a_2_54# 0 6.27999f **FLOATING
C974 OAI21X1_98/a_2_6# 0 2.78652f **FLOATING
C975 OAI21X1_98/Y 0 9.366751f **FLOATING
C976 OAI21X1_76/a_2_6# 0 2.78652f **FLOATING
C977 OAI21X1_87/a_2_6# 0 2.78652f **FLOATING
C978 OAI21X1_65/a_2_6# 0 2.78652f **FLOATING
C979 OAI21X1_54/a_2_6# 0 2.78652f **FLOATING
C980 OAI21X1_43/a_2_6# 0 2.78652f **FLOATING
C981 INVX2_115/Y 0 11.644679f **FLOATING
C982 OAI21X1_21/a_2_6# 0 2.78652f **FLOATING
C983 OAI21X1_32/a_2_6# 0 2.78652f **FLOATING
C984 OAI21X1_10/a_2_6# 0 2.78652f **FLOATING
C985 INVX2_80/Y 0 5.61768f **FLOATING
C986 NAND2X1_48/A 0 9.258901f **FLOATING
C987 LATCH_1/a_23_6# 0 6.09987f **FLOATING
C988 LATCH_1/a_2_6# 0 6.82959f **FLOATING
C989 NOR2X1_56/Y 0 9.37722f **FLOATING
C990 NOR2X1_45/Y 0 37.25873f **FLOATING
C991 INVX2_108/A 0 12.501901f **FLOATING
C992 HAX1_0/a_38_6# 0 2.442f **FLOATING
C993 HAX1_0/a_41_74# 0 5.99325f **FLOATING
C994 HAX1_0/a_2_74# 0 7.65318f **FLOATING
C995 AND2X2_23/a_2_6# 0 6.03567f **FLOATING
C996 AND2X2_12/a_2_6# 0 6.03567f **FLOATING
C997 OR2X1_13/a_2_54# 0 6.27999f **FLOATING
C998 OAI21X1_97/a_2_6# 0 2.78652f **FLOATING
C999 OAI21X1_75/a_2_6# 0 2.78652f **FLOATING
C1000 OAI21X1_86/a_2_6# 0 2.78652f **FLOATING
C1001 OAI21X1_64/a_2_6# 0 2.78652f **FLOATING
C1002 OAI21X1_53/a_2_6# 0 2.78652f **FLOATING
C1003 OAI21X1_42/a_2_6# 0 2.78652f **FLOATING
C1004 OAI21X1_31/a_2_6# 0 2.78652f **FLOATING
C1005 OAI21X1_20/a_2_6# 0 2.78652f **FLOATING
C1006 OR2X1_16/Y 0 13.412736f **FLOATING
C1007 XNOR2X1_3/Y 0 7.93215f **FLOATING
C1008 LATCH_0/a_23_6# 0 6.09987f **FLOATING
C1009 LATCH_0/a_2_6# 0 6.82959f **FLOATING
C1010 NOR2X1_44/Y 0 11.199571f **FLOATING
C1011 OR2X1_8/B 0 37.37484f **FLOATING
C1012 AND2X2_11/a_2_6# 0 6.03567f **FLOATING
C1013 AND2X2_22/a_2_6# 0 6.03567f **FLOATING
C1014 LATCH_2/Q 0 8.11062f **FLOATING
C1015 OR2X1_12/a_2_54# 0 6.27999f **FLOATING
C1016 OAI21X1_85/a_2_6# 0 2.78652f **FLOATING
C1017 OAI21X1_74/a_2_6# 0 2.78652f **FLOATING
C1018 OAI21X1_74/C 0 6.86169f **FLOATING
C1019 OAI21X1_96/a_2_6# 0 2.78652f **FLOATING
C1020 OAI21X1_63/a_2_6# 0 2.78652f **FLOATING
C1021 OAI21X1_41/a_2_6# 0 2.78652f **FLOATING
C1022 OAI21X1_52/a_2_6# 0 2.78652f **FLOATING
C1023 OAI21X1_30/a_2_6# 0 2.78652f **FLOATING
C1024 OR2X1_9/a_2_54# 0 6.27999f **FLOATING
C1025 shield_hp[1] 0 43.715595f **FLOATING
C1026 OR2X1_2/A 0 8.791141f **FLOATING
C1027 INVX2_51/A 0 14.2791f **FLOATING
C1028 AND2X2_10/a_2_6# 0 6.03567f **FLOATING
C1029 AND2X2_21/Y 0 11.65125f **FLOATING
C1030 AND2X2_21/a_2_6# 0 6.03567f **FLOATING
C1031 LATCH_1/Q 0 8.954939f **FLOATING
C1032 OR2X1_11/a_2_54# 0 6.27999f **FLOATING
C1033 OAI21X1_84/a_2_6# 0 2.78652f **FLOATING
C1034 OAI21X1_95/a_2_6# 0 2.78652f **FLOATING
C1035 OAI21X1_73/a_2_6# 0 2.78652f **FLOATING
C1036 OAI21X1_62/a_2_6# 0 2.78652f **FLOATING
C1037 OAI21X1_40/a_2_6# 0 2.78652f **FLOATING
C1038 OAI21X1_51/a_2_6# 0 2.78652f **FLOATING
C1039 OAI21X1_51/Y 0 8.81793f **FLOATING
C1040 OR2X1_8/a_2_54# 0 6.27999f **FLOATING
C1041 NAND2X1_8/Y 0 8.158319f **FLOATING
C1042 OAI21X1_6/C 0 10.11165f **FLOATING
C1043 AND2X2_20/a_2_6# 0 6.03567f **FLOATING
C1044 OR2X1_10/a_2_54# 0 6.27999f **FLOATING
C1045 OAI21X1_83/a_2_6# 0 2.78652f **FLOATING
C1046 OAI21X1_94/a_2_6# 0 2.78652f **FLOATING
C1047 OAI21X1_72/a_2_6# 0 2.78652f **FLOATING
C1048 OAI21X1_61/a_2_6# 0 2.78652f **FLOATING
C1049 OAI21X1_50/a_2_6# 0 2.78652f **FLOATING
C1050 INVX2_69/Y 0 8.100419f **FLOATING
C1051 OR2X1_7/Y 0 11.5527f **FLOATING
C1052 OR2X1_7/a_2_54# 0 6.27999f **FLOATING
C1053 OAI21X1_60/C 0 8.8029f **FLOATING
C1054 NOR2X1_30/Y 0 9.511199f **FLOATING
C1055 INVX2_1/Y 0 7.66704f **FLOATING
C1056 INVX2_63/A 0 13.622371f **FLOATING
C1057 OR2X1_20/a_2_54# 0 6.27999f **FLOATING
C1058 OR2X1_20/A 0 20.368212f **FLOATING
C1059 OAI21X1_82/a_2_6# 0 2.78652f **FLOATING
C1060 OAI21X1_93/a_2_6# 0 2.78652f **FLOATING
C1061 OAI21X1_71/a_2_6# 0 2.78652f **FLOATING
C1062 OAI21X1_71/Y 0 14.853602f **FLOATING
C1063 OAI21X1_60/a_2_6# 0 2.78652f **FLOATING
C1064 INVX2_65/Y 0 14.369862f **FLOATING
C1065 OR2X1_6/Y 0 7.11072f **FLOATING
C1066 OR2X1_6/a_2_54# 0 6.27999f **FLOATING
C1067 AOI21X1_19/a_2_54# 0 4.3068f **FLOATING
C1068 INVX2_147/A 0 18.647612f **FLOATING
C1069 OAI21X1_92/a_2_6# 0 2.78652f **FLOATING
C1070 OAI21X1_70/a_2_6# 0 2.78652f **FLOATING
C1071 OAI21X1_81/a_2_6# 0 2.78652f **FLOATING
C1072 OR2X1_5/a_2_54# 0 6.27999f **FLOATING
C1073 AOI21X1_18/a_2_54# 0 4.3068f **FLOATING
C1074 AOI21X1_29/a_2_54# 0 4.3068f **FLOATING
C1075 reset 0 34.640415f **FLOATING
C1076 OAI21X1_91/a_2_6# 0 2.78652f **FLOATING
C1077 OAI21X1_80/a_2_6# 0 2.78652f **FLOATING
C1078 OR2X1_4/a_2_54# 0 6.27999f **FLOATING
C1079 AOI21X1_28/a_2_54# 0 4.3068f **FLOATING
C1080 AOI21X1_17/a_2_54# 0 4.3068f **FLOATING
C1081 NOR2X1_7/Y 0 11.62881f **FLOATING
C1082 AOI21X1_9/a_2_54# 0 4.3068f **FLOATING
C1083 INVX2_9/Y 0 12.20799f **FLOATING
C1084 INVX2_145/A 0 13.192769f **FLOATING
C1085 NOR2X1_10/Y 0 18.43737f **FLOATING
C1086 OAI21X1_90/a_2_6# 0 2.78652f **FLOATING
C1087 DFFNEGX1_9/a_66_6# 0 6.40992f **FLOATING
C1088 DFFNEGX1_9/a_23_6# 0 6.85692f **FLOATING
C1089 DFFNEGX1_9/a_34_4# 0 4.93023f **FLOATING
C1090 DFFNEGX1_9/a_2_6# 0 9.33504f **FLOATING
C1091 OR2X1_3/a_2_54# 0 6.27999f **FLOATING
C1092 AOI21X1_27/a_2_54# 0 4.3068f **FLOATING
C1093 AOI21X1_16/a_2_54# 0 4.3068f **FLOATING
C1094 AOI21X1_8/a_2_54# 0 4.3068f **FLOATING
C1095 NAND2X1_4/Y 0 6.46521f **FLOATING
C1096 OAI21X1_83/C 0 10.25205f **FLOATING
C1097 OAI21X1_80/C 0 8.280899f **FLOATING
C1098 INVX2_5/Y 0 9.518579f **FLOATING
C1099 DFFNEGX1_8/a_66_6# 0 6.40992f **FLOATING
C1100 DFFNEGX1_8/a_23_6# 0 6.85692f **FLOATING
C1101 DFFNEGX1_8/a_34_4# 0 4.93023f **FLOATING
C1102 DFFNEGX1_8/a_2_6# 0 9.33504f **FLOATING
C1103 OR2X1_2/a_2_54# 0 6.27999f **FLOATING
C1104 AOI21X1_15/a_2_54# 0 4.3068f **FLOATING
C1105 AOI21X1_26/a_2_54# 0 4.3068f **FLOATING
C1106 AOI21X1_7/a_2_54# 0 4.3068f **FLOATING
C1107 NOR2X1_8/Y 0 16.92639f **FLOATING
C1108 NAND3X1_19/Y 0 8.38461f **FLOATING
C1109 BUFX2_7/a_2_6# 0 5.63946f **FLOATING
C1110 OAI21X1_109/a_2_6# 0 2.78652f **FLOATING
C1111 NAND2X1_78/Y 0 8.81904f **FLOATING
C1112 DFFNEGX1_7/a_66_6# 0 6.40992f **FLOATING
C1113 DFFNEGX1_7/a_23_6# 0 6.85692f **FLOATING
C1114 DFFNEGX1_7/a_34_4# 0 4.93023f **FLOATING
C1115 DFFNEGX1_7/a_2_6# 0 9.33504f **FLOATING
C1116 NOR2X1_18/Y 0 11.74197f **FLOATING
C1117 INVX2_71/Y 0 17.784302f **FLOATING
C1118 OAI21X1_9/a_2_6# 0 2.78652f **FLOATING
C1119 OR2X1_1/a_2_54# 0 6.27999f **FLOATING
C1120 HAX1_17/a_38_6# 0 2.442f **FLOATING
C1121 INVX2_45/A 0 15.18363f **FLOATING
C1122 HAX1_17/a_41_74# 0 5.99325f **FLOATING
C1123 HAX1_17/a_2_74# 0 7.65318f **FLOATING
C1124 AOI21X1_14/a_2_54# 0 4.3068f **FLOATING
C1125 INVX2_81/A 0 8.57202f **FLOATING
C1126 AOI21X1_25/a_2_54# 0 4.3068f **FLOATING
C1127 NOR2X1_4/Y 0 6.90723f **FLOATING
C1128 AOI21X1_6/a_2_54# 0 4.3068f **FLOATING
C1129 INVX2_157/A 0 9.169139f **FLOATING
C1130 BUFX2_6/a_2_6# 0 5.63946f **FLOATING
C1131 OAI21X1_119/a_2_6# 0 2.78652f **FLOATING
C1132 OAI21X1_119/Y 0 8.730359f **FLOATING
C1133 OAI21X1_108/a_2_6# 0 2.78652f **FLOATING
C1134 INVX2_155/A 0 10.505221f **FLOATING
C1135 DFFNEGX1_6/a_66_6# 0 6.40992f **FLOATING
C1136 DFFNEGX1_6/a_23_6# 0 6.85692f **FLOATING
C1137 DFFNEGX1_6/a_34_4# 0 4.93023f **FLOATING
C1138 DFFNEGX1_6/a_2_6# 0 9.33504f **FLOATING
C1139 OR2X1_0/a_2_54# 0 6.27999f **FLOATING
C1140 OAI21X1_8/a_2_6# 0 2.78652f **FLOATING
C1141 INVX2_40/A 0 9.1413f **FLOATING
C1142 HAX1_16/a_38_6# 0 2.442f **FLOATING
C1143 HAX1_16/a_41_74# 0 5.99325f **FLOATING
C1144 HAX1_16/a_2_74# 0 7.65318f **FLOATING
C1145 AOI21X1_24/a_2_54# 0 4.3068f **FLOATING
C1146 INVX2_59/Y 0 18.780392f **FLOATING
C1147 AOI21X1_13/a_2_54# 0 4.3068f **FLOATING
C1148 AOI21X1_5/a_2_54# 0 4.3068f **FLOATING
C1149 INVX2_29/A 0 27.22304f **FLOATING
C1150 BUFX2_5/a_2_6# 0 5.63946f **FLOATING
C1151 OAI21X1_118/a_2_6# 0 2.78652f **FLOATING
C1152 AOI22X1_45/B 0 11.865782f **FLOATING
C1153 OAI21X1_107/a_2_6# 0 2.78652f **FLOATING
C1154 OR2X1_14/B 0 6.81228f **FLOATING
C1155 OAI21X1_129/a_2_6# 0 2.78652f **FLOATING
C1156 INVX2_175/Y 0 60.83949f **FLOATING
C1157 OAI21X1_77/C 0 7.410901f **FLOATING
C1158 shield_coord_y[0] 0 44.947514f **FLOATING
C1159 AOI22X1_5/Y 0 7.77282f **FLOATING
C1160 INVX2_128/A 0 32.77773f **FLOATING
C1161 INVX2_25/Y 0 34.028336f **FLOATING
C1162 DFFNEGX1_5/a_66_6# 0 6.40992f **FLOATING
C1163 DFFNEGX1_5/a_23_6# 0 6.85692f **FLOATING
C1164 DFFNEGX1_5/a_34_4# 0 4.93023f **FLOATING
C1165 DFFNEGX1_5/a_2_6# 0 9.33504f **FLOATING
C1166 OAI21X1_42/Y 0 11.773561f **FLOATING
C1167 OAI21X1_7/a_2_6# 0 2.78652f **FLOATING
C1168 HAX1_15/a_38_6# 0 2.442f **FLOATING
C1169 HAX1_15/a_41_74# 0 5.99325f **FLOATING
C1170 HAX1_15/a_2_74# 0 7.65318f **FLOATING
C1171 AOI21X1_12/a_2_54# 0 4.3068f **FLOATING
C1172 AOI21X1_23/a_2_54# 0 4.3068f **FLOATING
C1173 AOI21X1_4/a_2_54# 0 4.3068f **FLOATING
C1174 OAI21X1_67/Y 0 10.73118f **FLOATING
C1175 BUFX2_4/a_2_6# 0 5.63946f **FLOATING
C1176 OAI21X1_139/a_2_6# 0 2.78652f **FLOATING
C1177 OAI21X1_117/a_2_6# 0 2.78652f **FLOATING
C1178 OAI21X1_128/a_2_6# 0 2.78652f **FLOATING
C1179 NAND2X1_64/Y 0 11.27079f **FLOATING
C1180 OAI21X1_106/a_2_6# 0 2.78652f **FLOATING
C1181 OAI21X1_106/Y 0 9.74796f **FLOATING
C1182 OAI21X1_72/Y 0 13.859461f **FLOATING
C1183 INVX2_116/Y 0 8.510699f **FLOATING
C1184 INVX2_116/A 0 25.468378f **FLOATING
C1185 INVX2_127/Y 0 5.61768f **FLOATING
C1186 XOR2X1_9/Y 0 11.45358f **FLOATING
C1187 XOR2X1_9/a_2_6# 0 8.278139f **FLOATING
C1188 XOR2X1_9/a_13_43# 0 7.836241f **FLOATING
C1189 DFFNEGX1_4/a_66_6# 0 6.40992f **FLOATING
C1190 DFFNEGX1_4/a_23_6# 0 6.85692f **FLOATING
C1191 DFFNEGX1_4/a_34_4# 0 4.93023f **FLOATING
C1192 DFFNEGX1_4/a_2_6# 0 9.33504f **FLOATING
C1193 OAI21X1_6/a_2_6# 0 2.78652f **FLOATING
C1194 AOI21X1_11/a_2_54# 0 4.3068f **FLOATING
C1195 HAX1_14/a_38_6# 0 2.442f **FLOATING
C1196 HAX1_13/B 0 11.750401f **FLOATING
C1197 HAX1_14/a_41_74# 0 5.99325f **FLOATING
C1198 HAX1_14/a_2_74# 0 7.65318f **FLOATING
C1199 AOI21X1_22/a_2_54# 0 4.3068f **FLOATING
C1200 INVX2_114/Y 0 10.37484f **FLOATING
C1201 NOR2X1_1/Y 0 14.018999f **FLOATING
C1202 AOI21X1_3/a_2_54# 0 4.3068f **FLOATING
C1203 BUFX2_3/a_2_6# 0 5.63946f **FLOATING
C1204 OAI21X1_149/a_2_6# 0 2.78652f **FLOATING
C1205 OAI21X1_138/a_2_6# 0 2.78652f **FLOATING
C1206 OAI21X1_116/a_2_6# 0 2.78652f **FLOATING
C1207 OAI21X1_127/a_2_6# 0 2.78652f **FLOATING
C1208 OAI21X1_105/a_2_6# 0 2.78652f **FLOATING
C1209 XOR2X1_19/a_2_6# 0 8.278139f **FLOATING
C1210 XOR2X1_19/a_13_43# 0 7.836241f **FLOATING
C1211 INVX2_126/Y 0 5.717219f **FLOATING
C1212 XOR2X1_8/a_2_6# 0 8.278139f **FLOATING
C1213 XOR2X1_8/a_13_43# 0 7.836241f **FLOATING
C1214 DFFNEGX1_3/a_66_6# 0 6.40992f **FLOATING
C1215 DFFNEGX1_3/a_23_6# 0 6.85692f **FLOATING
C1216 DFFNEGX1_3/a_34_4# 0 4.93023f **FLOATING
C1217 DFFNEGX1_3/a_2_6# 0 9.33504f **FLOATING
C1218 OAI21X1_5/a_2_6# 0 2.78652f **FLOATING
C1219 HAX1_13/a_38_6# 0 2.442f **FLOATING
C1220 HAX1_13/a_41_74# 0 5.99325f **FLOATING
C1221 HAX1_13/a_2_74# 0 7.65318f **FLOATING
C1222 AOI21X1_21/a_2_54# 0 4.3068f **FLOATING
C1223 AOI21X1_10/a_2_54# 0 4.3068f **FLOATING
C1224 NOR2X1_0/Y 0 10.845901f **FLOATING
C1225 AOI21X1_2/a_2_54# 0 4.3068f **FLOATING
C1226 NOR2X1_45/A 0 18.973171f **FLOATING
C1227 OAI21X1_71/C 0 8.96445f **FLOATING
C1228 BUFX2_2/a_2_6# 0 5.63946f **FLOATING
C1229 OAI21X1_148/a_2_6# 0 2.78652f **FLOATING
C1230 OAI21X1_137/a_2_6# 0 2.78652f **FLOATING
C1231 OAI21X1_115/a_2_6# 0 2.78652f **FLOATING
C1232 OAI21X1_126/a_2_6# 0 2.78652f **FLOATING
C1233 AOI21X1_28/Y 0 6.63948f **FLOATING
C1234 OAI21X1_104/a_2_6# 0 2.78652f **FLOATING
C1235 XOR2X1_18/a_2_6# 0 8.278139f **FLOATING
C1236 XOR2X1_18/a_13_43# 0 7.836241f **FLOATING
C1237 XOR2X1_19/Y 0 15.542579f **FLOATING
C1238 INVX2_114/A 0 11.650829f **FLOATING
C1239 NAND2X1_53/Y 0 11.873099f **FLOATING
C1240 XOR2X1_7/a_2_6# 0 8.278139f **FLOATING
C1241 XOR2X1_7/a_13_43# 0 7.836241f **FLOATING
C1242 DFFNEGX1_2/a_66_6# 0 6.40992f **FLOATING
C1243 DFFNEGX1_2/a_23_6# 0 6.85692f **FLOATING
C1244 DFFNEGX1_2/a_34_4# 0 4.93023f **FLOATING
C1245 DFFNEGX1_2/a_2_6# 0 9.33504f **FLOATING
C1246 OAI21X1_4/a_2_6# 0 2.78652f **FLOATING
C1247 AOI21X1_20/a_2_54# 0 4.3068f **FLOATING
C1248 HAX1_12/a_38_6# 0 2.442f **FLOATING
C1249 HAX1_12/a_41_74# 0 5.99325f **FLOATING
C1250 HAX1_12/a_2_74# 0 7.65318f **FLOATING
C1251 AOI21X1_31/a_2_54# 0 4.3068f **FLOATING
C1252 AOI21X1_1/a_2_54# 0 4.3068f **FLOATING
C1253 BUFX2_1/a_2_6# 0 5.63946f **FLOATING
C1254 OAI21X1_136/a_2_6# 0 2.78652f **FLOATING
C1255 INVX2_111/Y 0 6.012059f **FLOATING
C1256 OAI21X1_114/a_2_6# 0 2.78652f **FLOATING
C1257 AOI22X1_45/D 0 8.53548f **FLOATING
C1258 OAI21X1_125/a_2_6# 0 2.78652f **FLOATING
C1259 OAI21X1_125/Y 0 8.81793f **FLOATING
C1260 INVX2_166/Y 0 6.012059f **FLOATING
C1261 OAI21X1_147/a_2_6# 0 2.78652f **FLOATING
C1262 OAI21X1_103/a_2_6# 0 2.78652f **FLOATING
C1263 AOI22X1_39/D 0 8.909221f **FLOATING
C1264 NOR2X1_36/Y 0 9.912842f **FLOATING
C1265 XOR2X1_17/Y 0 9.09939f **FLOATING
C1266 XOR2X1_17/a_2_6# 0 8.278139f **FLOATING
C1267 XOR2X1_17/a_13_43# 0 7.836241f **FLOATING
C1268 DFFNEGX1_19/a_66_6# 0 6.40992f **FLOATING
C1269 DFFNEGX1_19/a_23_6# 0 6.85692f **FLOATING
C1270 DFFNEGX1_19/a_34_4# 0 4.93023f **FLOATING
C1271 DFFNEGX1_19/a_2_6# 0 9.33504f **FLOATING
C1272 INVX2_140/Y 0 12.9315f **FLOATING
C1273 INVX2_146/Y 0 5.92962f **FLOATING
C1274 XOR2X1_16/A 0 14.013091f **FLOATING
C1275 INVX2_113/Y 0 6.01206f **FLOATING
C1276 XOR2X1_6/Y 0 7.725629f **FLOATING
C1277 XOR2X1_6/a_2_6# 0 8.278139f **FLOATING
C1278 XOR2X1_6/a_13_43# 0 7.836241f **FLOATING
C1279 DFFNEGX1_1/a_66_6# 0 6.40992f **FLOATING
C1280 invader_bullet_coord_y[3] 0 66.72755f **FLOATING
C1281 DFFNEGX1_1/a_23_6# 0 6.85692f **FLOATING
C1282 DFFNEGX1_1/a_34_4# 0 4.93023f **FLOATING
C1283 DFFNEGX1_1/a_2_6# 0 9.33504f **FLOATING
C1284 OAI21X1_3/a_2_6# 0 2.78652f **FLOATING
C1285 OAI21X1_4/Y 0 14.01066f **FLOATING
C1286 AOI21X1_30/a_2_54# 0 4.3068f **FLOATING
C1287 HAX1_11/a_38_6# 0 2.442f **FLOATING
C1288 HAX1_11/a_41_74# 0 5.99325f **FLOATING
C1289 HAX1_11/a_2_74# 0 7.65318f **FLOATING
C1290 INVX2_158/Y 0 9.12216f **FLOATING
C1291 AOI21X1_0/a_2_54# 0 4.3068f **FLOATING
C1292 AOI22X1_19/a_2_54# 0 6.66f **FLOATING
C1293 XNOR2X1_0/Y 0 22.887087f **FLOATING
C1294 OAI21X1_70/C 0 12.257249f **FLOATING
C1295 BUFX2_0/a_2_6# 0 5.63946f **FLOATING
C1296 OAI21X1_135/a_2_6# 0 2.78652f **FLOATING
C1297 OAI21X1_124/a_2_6# 0 2.78652f **FLOATING
C1298 OR2X1_18/B 0 6.81228f **FLOATING
C1299 OAI21X1_146/a_2_6# 0 2.78652f **FLOATING
C1300 AOI21X1_31/B 0 6.490321f **FLOATING
C1301 OAI21X1_102/a_2_6# 0 2.78652f **FLOATING
C1302 OAI21X1_113/a_2_6# 0 2.78652f **FLOATING
C1303 XOR2X1_16/a_2_6# 0 8.278139f **FLOATING
C1304 XOR2X1_16/a_13_43# 0 7.836241f **FLOATING
C1305 INVX2_84/A 0 28.15329f **FLOATING
C1306 DFFNEGX1_29/a_66_6# 0 6.40992f **FLOATING
C1307 DFFNEGX1_29/a_23_6# 0 6.85692f **FLOATING
C1308 DFFNEGX1_29/a_34_4# 0 4.93023f **FLOATING
C1309 DFFNEGX1_29/a_2_6# 0 9.33504f **FLOATING
C1310 DFFNEGX1_18/a_66_6# 0 6.40992f **FLOATING
C1311 DFFNEGX1_18/a_23_6# 0 6.85692f **FLOATING
C1312 DFFNEGX1_18/a_34_4# 0 4.93023f **FLOATING
C1313 DFFNEGX1_18/a_2_6# 0 9.33504f **FLOATING
C1314 INVX2_141/Y 0 13.775821f **FLOATING
C1315 HAX1_4/YS 0 22.520111f **FLOATING
C1316 INVX2_156/Y 0 5.92962f **FLOATING
C1317 INVX2_145/Y 0 8.827081f **FLOATING
C1318 AND2X2_22/Y 0 20.81145f **FLOATING
C1319 NAND2X1_59/Y 0 8.651821f **FLOATING
C1320 XOR2X1_5/a_2_6# 0 8.278139f **FLOATING
C1321 XOR2X1_5/a_13_43# 0 7.836241f **FLOATING
C1322 DFFNEGX1_0/a_66_6# 0 6.40992f **FLOATING
C1323 DFFNEGX1_0/a_23_6# 0 6.85692f **FLOATING
C1324 DFFNEGX1_0/a_34_4# 0 4.93023f **FLOATING
C1325 DFFNEGX1_0/a_2_6# 0 9.33504f **FLOATING
C1326 OAI21X1_46/Y 0 11.94726f **FLOATING
C1327 OAI21X1_2/a_2_6# 0 2.78652f **FLOATING
C1328 HAX1_10/a_38_6# 0 2.442f **FLOATING
C1329 HAX1_10/a_41_74# 0 5.99325f **FLOATING
C1330 HAX1_10/a_2_74# 0 7.65318f **FLOATING
C1331 INVX2_157/Y 0 7.22106f **FLOATING
C1332 AOI22X1_29/a_2_54# 0 6.66f **FLOATING
C1333 AOI22X1_18/a_2_54# 0 6.66f **FLOATING
C1334 OAI21X1_134/a_2_6# 0 2.78652f **FLOATING
C1335 OAI21X1_145/a_2_6# 0 2.78652f **FLOATING
C1336 OAI21X1_123/a_2_6# 0 2.78652f **FLOATING
C1337 NAND2X1_62/Y 0 11.46264f **FLOATING
C1338 OAI21X1_101/a_2_6# 0 2.78652f **FLOATING
C1339 AND2X2_18/B 0 33.37349f **FLOATING
C1340 OAI21X1_112/a_2_6# 0 2.78652f **FLOATING
C1341 XOR2X1_15/a_2_6# 0 8.278139f **FLOATING
C1342 XOR2X1_15/a_13_43# 0 7.836241f **FLOATING
C1343 DFFNEGX1_39/a_66_6# 0 6.40992f **FLOATING
C1344 DFFNEGX1_39/a_23_6# 0 6.85692f **FLOATING
C1345 DFFNEGX1_39/a_34_4# 0 4.93023f **FLOATING
C1346 DFFNEGX1_39/a_2_6# 0 9.33504f **FLOATING
C1347 DFFNEGX1_28/a_66_6# 0 6.40992f **FLOATING
C1348 DFFNEGX1_28/a_23_6# 0 6.85692f **FLOATING
C1349 DFFNEGX1_28/a_34_4# 0 4.93023f **FLOATING
C1350 DFFNEGX1_28/a_2_6# 0 9.33504f **FLOATING
C1351 DFFNEGX1_17/a_66_6# 0 6.40992f **FLOATING
C1352 DFFNEGX1_17/a_23_6# 0 6.85692f **FLOATING
C1353 DFFNEGX1_17/a_34_4# 0 4.93023f **FLOATING
C1354 DFFNEGX1_17/a_2_6# 0 9.33504f **FLOATING
C1355 INVX2_142/Y 0 12.55518f **FLOATING
C1356 gnd 0 2.971917p **FLOATING
C1357 INVX2_144/Y 0 39.546185f **FLOATING
C1358 INVX2_124/A 0 31.333565f **FLOATING
C1359 XOR2X1_4/a_2_6# 0 8.278139f **FLOATING
C1360 XOR2X1_4/a_13_43# 0 7.836241f **FLOATING
C1361 OAI21X1_1/a_2_6# 0 2.78652f **FLOATING
C1362 OAI21X1_1/Y 0 12.410912f **FLOATING
C1363 INVX2_169/Y 0 11.918098f **FLOATING
C1364 AOI22X1_28/a_2_54# 0 6.66f **FLOATING
C1365 AOI22X1_17/a_2_54# 0 6.66f **FLOATING
C1366 AOI22X1_39/a_2_54# 0 6.66f **FLOATING
C1367 NAND3X1_5/A 0 12.4872f **FLOATING
C1368 OAI21X1_133/a_2_6# 0 2.78652f **FLOATING
C1369 OAI21X1_134/Y 0 10.513741f **FLOATING
C1370 INVX2_109/Y 0 6.012059f **FLOATING
C1371 OAI21X1_144/a_2_6# 0 2.78652f **FLOATING
C1372 AOI22X1_9/a_2_54# 0 6.66f **FLOATING
C1373 OAI21X1_122/a_2_6# 0 2.78652f **FLOATING
C1374 OAI21X1_122/Y 0 12.713639f **FLOATING
C1375 OAI21X1_100/a_2_6# 0 2.78652f **FLOATING
C1376 OAI21X1_111/a_2_6# 0 2.78652f **FLOATING
C1377 XOR2X1_14/Y 0 10.311419f **FLOATING
C1378 XOR2X1_14/a_2_6# 0 8.278139f **FLOATING
C1379 XOR2X1_14/a_13_43# 0 7.836241f **FLOATING
C1380 DFFNEGX1_38/a_66_6# 0 6.40992f **FLOATING
C1381 DFFNEGX1_38/a_23_6# 0 6.85692f **FLOATING
C1382 DFFNEGX1_38/a_34_4# 0 4.93023f **FLOATING
C1383 DFFNEGX1_38/a_2_6# 0 9.33504f **FLOATING
C1384 DFFNEGX1_27/a_66_6# 0 6.40992f **FLOATING
C1385 DFFNEGX1_27/a_23_6# 0 6.85692f **FLOATING
C1386 DFFNEGX1_27/a_34_4# 0 4.93023f **FLOATING
C1387 DFFNEGX1_27/a_2_6# 0 9.33504f **FLOATING
C1388 DFFNEGX1_49/a_66_6# 0 6.40992f **FLOATING
C1389 DFFNEGX1_49/a_23_6# 0 6.85692f **FLOATING
C1390 DFFNEGX1_49/a_34_4# 0 4.93023f **FLOATING
C1391 DFFNEGX1_49/a_2_6# 0 9.33504f **FLOATING
C1392 OAI21X1_83/Y 0 13.5825f **FLOATING
C1393 DFFNEGX1_16/a_66_6# 0 6.40992f **FLOATING
C1394 DFFNEGX1_16/a_23_6# 0 6.85692f **FLOATING
C1395 DFFNEGX1_16/a_34_4# 0 4.93023f **FLOATING
C1396 DFFNEGX1_16/a_2_6# 0 9.33504f **FLOATING
C1397 INVX2_132/Y 0 12.44418f **FLOATING
C1398 NOR2X1_55/Y 0 11.488501f **FLOATING
C1399 NAND2X1_52/Y 0 11.350441f **FLOATING
C1400 invader_bullet_coord_x[2] 0 52.768867f **FLOATING
C1401 XOR2X1_3/a_2_6# 0 8.278139f **FLOATING
C1402 XOR2X1_3/a_13_43# 0 7.836241f **FLOATING
C1403 OAI21X1_0/a_2_6# 0 2.78652f **FLOATING
C1404 INVX2_161/Y 0 23.49834f **FLOATING
C1405 AOI22X1_49/a_2_54# 0 6.66f **FLOATING
C1406 INVX2_158/A 0 28.246155f **FLOATING
C1407 AOI22X1_49/A 0 7.88283f **FLOATING
C1408 AOI22X1_27/a_2_54# 0 6.66f **FLOATING
C1409 AND2X2_9/Y 0 22.524958f **FLOATING
C1410 AOI22X1_16/a_2_54# 0 6.66f **FLOATING
C1411 AOI22X1_38/a_2_54# 0 6.66f **FLOATING
C1412 OAI21X1_132/a_2_6# 0 2.78652f **FLOATING
C1413 OAI21X1_143/a_2_6# 0 2.78652f **FLOATING
C1414 AOI22X1_8/a_2_54# 0 6.66f **FLOATING
C1415 OAI21X1_154/a_2_6# 0 2.78652f **FLOATING
C1416 INVX2_127/A 0 27.041807f **FLOATING
C1417 OAI21X1_121/a_2_6# 0 2.78652f **FLOATING
C1418 OAI21X1_110/a_2_6# 0 2.78652f **FLOATING
C1419 XOR2X1_13/a_2_6# 0 8.278139f **FLOATING
C1420 XOR2X1_13/a_13_43# 0 7.836241f **FLOATING
C1421 DFFNEGX1_48/a_66_6# 0 6.40992f **FLOATING
C1422 DFFNEGX1_48/a_23_6# 0 6.85692f **FLOATING
C1423 DFFNEGX1_48/a_34_4# 0 4.93023f **FLOATING
C1424 DFFNEGX1_48/a_2_6# 0 9.33504f **FLOATING
C1425 DFFNEGX1_26/a_66_6# 0 6.40992f **FLOATING
C1426 DFFNEGX1_26/a_23_6# 0 6.85692f **FLOATING
C1427 DFFNEGX1_26/a_34_4# 0 4.93023f **FLOATING
C1428 DFFNEGX1_26/a_2_6# 0 9.33504f **FLOATING
C1429 DFFNEGX1_37/a_66_6# 0 6.40992f **FLOATING
C1430 DFFNEGX1_37/a_23_6# 0 6.85692f **FLOATING
C1431 DFFNEGX1_37/a_34_4# 0 4.93023f **FLOATING
C1432 DFFNEGX1_37/a_2_6# 0 9.33504f **FLOATING
C1433 DFFNEGX1_59/a_66_6# 0 6.40992f **FLOATING
C1434 DFFNEGX1_59/a_23_6# 0 6.85692f **FLOATING
C1435 DFFNEGX1_59/a_34_4# 0 4.93023f **FLOATING
C1436 DFFNEGX1_59/a_2_6# 0 9.33504f **FLOATING
C1437 DFFNEGX1_15/a_66_6# 0 6.40992f **FLOATING
C1438 DFFNEGX1_15/a_23_6# 0 6.85692f **FLOATING
C1439 DFFNEGX1_15/a_34_4# 0 4.93023f **FLOATING
C1440 DFFNEGX1_15/a_2_6# 0 9.33504f **FLOATING
C1441 HAX1_5/YS 0 24.61791f **FLOATING
C1442 INVX2_164/Y 0 6.01206f **FLOATING
C1443 XOR2X1_2/a_2_6# 0 8.278139f **FLOATING
C1444 XOR2X1_2/a_13_43# 0 7.836241f **FLOATING
C1445 AOI22X1_59/a_2_54# 0 6.66f **FLOATING
C1446 AOI22X1_26/a_2_54# 0 6.66f **FLOATING
C1447 AOI22X1_37/a_2_54# 0 6.66f **FLOATING
C1448 AOI22X1_48/a_2_54# 0 6.66f **FLOATING
C1449 AOI22X1_15/a_2_54# 0 6.66f **FLOATING
C1450 OAI21X1_68/B 0 6.5403f **FLOATING
C1451 OAI21X1_153/a_2_6# 0 2.78652f **FLOATING
C1452 OAI21X1_142/a_2_6# 0 2.78652f **FLOATING
C1453 NAND2X1_74/Y 0 25.020061f **FLOATING
C1454 AOI22X1_7/a_2_54# 0 6.66f **FLOATING
C1455 OAI21X1_131/a_2_6# 0 2.78652f **FLOATING
C1456 OAI21X1_120/a_2_6# 0 2.78652f **FLOATING
C1457 AOI22X1_46/B 0 12.683341f **FLOATING
C1458 XOR2X1_12/Y 0 7.996469f **FLOATING
C1459 XOR2X1_12/a_2_6# 0 8.278139f **FLOATING
C1460 XOR2X1_12/a_13_43# 0 7.836241f **FLOATING
C1461 DFFNEGX1_69/a_66_6# 0 6.40992f **FLOATING
C1462 DFFNEGX1_69/a_23_6# 0 6.85692f **FLOATING
C1463 DFFNEGX1_69/a_34_4# 0 4.93023f **FLOATING
C1464 DFFNEGX1_69/a_2_6# 0 9.33504f **FLOATING
C1465 INVX2_131/Y 0 28.32075f **FLOATING
C1466 DFFNEGX1_47/a_66_6# 0 6.40992f **FLOATING
C1467 DFFNEGX1_47/a_23_6# 0 6.85692f **FLOATING
C1468 DFFNEGX1_47/a_34_4# 0 4.93023f **FLOATING
C1469 DFFNEGX1_47/a_2_6# 0 9.33504f **FLOATING
C1470 DFFNEGX1_36/a_66_6# 0 6.40992f **FLOATING
C1471 DFFNEGX1_36/a_23_6# 0 6.85692f **FLOATING
C1472 DFFNEGX1_36/a_34_4# 0 4.93023f **FLOATING
C1473 DFFNEGX1_36/a_2_6# 0 9.33504f **FLOATING
C1474 OAI21X1_58/Y 0 12.43872f **FLOATING
C1475 DFFNEGX1_58/a_66_6# 0 6.40992f **FLOATING
C1476 DFFNEGX1_58/a_23_6# 0 6.85692f **FLOATING
C1477 DFFNEGX1_58/a_34_4# 0 4.93023f **FLOATING
C1478 DFFNEGX1_58/a_2_6# 0 9.33504f **FLOATING
C1479 DFFNEGX1_25/a_66_6# 0 6.40992f **FLOATING
C1480 DFFNEGX1_25/a_23_6# 0 6.85692f **FLOATING
C1481 DFFNEGX1_25/a_34_4# 0 4.93023f **FLOATING
C1482 DFFNEGX1_25/a_2_6# 0 9.33504f **FLOATING
C1483 DFFNEGX1_14/a_66_6# 0 6.40992f **FLOATING
C1484 DFFNEGX1_14/a_23_6# 0 6.85692f **FLOATING
C1485 DFFNEGX1_14/a_34_4# 0 4.93023f **FLOATING
C1486 DFFNEGX1_14/a_2_6# 0 9.33504f **FLOATING
C1487 AND2X2_0/A 0 49.775f **FLOATING
C1488 INVX2_152/A 0 18.00933f **FLOATING
C1489 XOR2X1_1/a_2_6# 0 8.278139f **FLOATING
C1490 XOR2X1_1/a_13_43# 0 7.836241f **FLOATING
C1491 OAI22X1_9/a_2_6# 0 4.25172f **FLOATING
C1492 AOI22X1_58/a_2_54# 0 6.66f **FLOATING
C1493 AOI22X1_25/a_2_54# 0 6.66f **FLOATING
C1494 AOI22X1_47/a_2_54# 0 6.66f **FLOATING
C1495 AOI22X1_36/a_2_54# 0 6.66f **FLOATING
C1496 AOI22X1_14/a_2_54# 0 6.66f **FLOATING
C1497 NOR2X1_43/Y 0 10.049161f **FLOATING
C1498 OAI21X1_152/a_2_6# 0 2.78652f **FLOATING
C1499 XNOR2X1_8/A 0 31.537043f **FLOATING
C1500 OAI21X1_141/a_2_6# 0 2.78652f **FLOATING
C1501 INVX2_106/A 0 17.12058f **FLOATING
C1502 AOI22X1_6/a_2_54# 0 6.66f **FLOATING
C1503 OAI21X1_130/a_2_6# 0 2.78652f **FLOATING
C1504 INVX2_126/A 0 20.042189f **FLOATING
C1505 INVX2_178/Y 0 13.458092f **FLOATING
C1506 XOR2X1_11/a_2_6# 0 8.278139f **FLOATING
C1507 XOR2X1_11/a_13_43# 0 7.836241f **FLOATING
C1508 INVX2_35/Y 0 7.85346f **FLOATING
C1509 DFFNEGX1_79/a_66_6# 0 6.40992f **FLOATING
C1510 DFFNEGX1_79/a_23_6# 0 6.85692f **FLOATING
C1511 DFFNEGX1_79/a_34_4# 0 4.93023f **FLOATING
C1512 DFFNEGX1_79/a_2_6# 0 9.33504f **FLOATING
C1513 DFFNEGX1_35/a_66_6# 0 6.40992f **FLOATING
C1514 DFFNEGX1_35/a_23_6# 0 6.85692f **FLOATING
C1515 DFFNEGX1_35/a_34_4# 0 4.93023f **FLOATING
C1516 DFFNEGX1_35/a_2_6# 0 9.33504f **FLOATING
C1517 DFFNEGX1_57/a_66_6# 0 6.40992f **FLOATING
C1518 DFFNEGX1_57/a_23_6# 0 6.85692f **FLOATING
C1519 DFFNEGX1_57/a_34_4# 0 4.93023f **FLOATING
C1520 DFFNEGX1_57/a_2_6# 0 9.33504f **FLOATING
C1521 DFFNEGX1_68/a_66_6# 0 6.40992f **FLOATING
C1522 DFFNEGX1_68/a_23_6# 0 6.85692f **FLOATING
C1523 DFFNEGX1_68/a_34_4# 0 4.93023f **FLOATING
C1524 DFFNEGX1_68/a_2_6# 0 9.33504f **FLOATING
C1525 DFFNEGX1_46/a_66_6# 0 6.40992f **FLOATING
C1526 DFFNEGX1_46/a_23_6# 0 6.85692f **FLOATING
C1527 DFFNEGX1_46/a_34_4# 0 4.93023f **FLOATING
C1528 DFFNEGX1_46/a_2_6# 0 9.33504f **FLOATING
C1529 DFFNEGX1_24/a_66_6# 0 6.40992f **FLOATING
C1530 DFFNEGX1_24/a_23_6# 0 6.85692f **FLOATING
C1531 DFFNEGX1_24/a_34_4# 0 4.93023f **FLOATING
C1532 DFFNEGX1_24/a_2_6# 0 9.33504f **FLOATING
C1533 DFFNEGX1_13/a_66_6# 0 6.40992f **FLOATING
C1534 DFFNEGX1_13/a_23_6# 0 6.85692f **FLOATING
C1535 DFFNEGX1_13/a_34_4# 0 4.93023f **FLOATING
C1536 DFFNEGX1_13/a_2_6# 0 9.33504f **FLOATING
C1537 NOR2X1_5/Y 0 15.454379f **FLOATING
C1538 INVX2_173/A 0 19.607521f **FLOATING
C1539 XOR2X1_0/a_2_6# 0 8.278139f **FLOATING
C1540 XOR2X1_0/a_13_43# 0 7.836241f **FLOATING
C1541 OAI22X1_8/a_2_6# 0 4.25172f **FLOATING
C1542 AOI22X1_57/a_2_54# 0 6.66f **FLOATING
C1543 INVX2_110/A 0 13.95861f **FLOATING
C1544 AOI22X1_35/a_2_54# 0 6.66f **FLOATING
C1545 AOI22X1_46/a_2_54# 0 6.66f **FLOATING
C1546 AOI22X1_24/a_2_54# 0 6.66f **FLOATING
C1547 AOI22X1_13/a_2_54# 0 6.66f **FLOATING
C1548 OAI22X1_4/B 0 34.765736f **FLOATING
C1549 NAND3X1_8/A 0 14.221261f **FLOATING
C1550 OAI21X1_151/a_2_6# 0 2.78652f **FLOATING
C1551 AOI22X1_5/a_2_54# 0 6.66f **FLOATING
C1552 OAI21X1_140/a_2_6# 0 2.78652f **FLOATING
C1553 OAI21X1_140/Y 0 8.730359f **FLOATING
C1554 XOR2X1_10/a_2_6# 0 8.278139f **FLOATING
C1555 XOR2X1_10/a_13_43# 0 7.836241f **FLOATING
C1556 INVX2_28/Y 0 10.53942f **FLOATING
C1557 DFFNEGX1_89/a_66_6# 0 6.40992f **FLOATING
C1558 DFFNEGX1_89/a_23_6# 0 6.85692f **FLOATING
C1559 DFFNEGX1_89/a_34_4# 0 4.93023f **FLOATING
C1560 DFFNEGX1_89/a_2_6# 0 9.33504f **FLOATING
C1561 DFFNEGX1_78/a_66_6# 0 6.40992f **FLOATING
C1562 DFFNEGX1_78/a_23_6# 0 6.85692f **FLOATING
C1563 DFFNEGX1_78/a_34_4# 0 4.93023f **FLOATING
C1564 DFFNEGX1_78/a_2_6# 0 9.33504f **FLOATING
C1565 DFFNEGX1_45/a_66_6# 0 6.40992f **FLOATING
C1566 DFFNEGX1_45/a_23_6# 0 6.85692f **FLOATING
C1567 DFFNEGX1_45/a_34_4# 0 4.93023f **FLOATING
C1568 DFFNEGX1_45/a_2_6# 0 9.33504f **FLOATING
C1569 DFFNEGX1_67/a_66_6# 0 6.40992f **FLOATING
C1570 DFFNEGX1_67/a_23_6# 0 6.85692f **FLOATING
C1571 DFFNEGX1_67/a_34_4# 0 4.93023f **FLOATING
C1572 DFFNEGX1_67/a_2_6# 0 9.33504f **FLOATING
C1573 DFFNEGX1_56/a_66_6# 0 6.40992f **FLOATING
C1574 DFFNEGX1_56/a_23_6# 0 6.85692f **FLOATING
C1575 DFFNEGX1_56/a_34_4# 0 4.93023f **FLOATING
C1576 DFFNEGX1_56/a_2_6# 0 9.33504f **FLOATING
C1577 DFFNEGX1_23/a_66_6# 0 6.40992f **FLOATING
C1578 DFFNEGX1_23/a_23_6# 0 6.85692f **FLOATING
C1579 DFFNEGX1_23/a_34_4# 0 4.93023f **FLOATING
C1580 DFFNEGX1_23/a_2_6# 0 9.33504f **FLOATING
C1581 DFFNEGX1_34/a_66_6# 0 6.40992f **FLOATING
C1582 invader_2_coord_x[2] 0 48.132786f **FLOATING
C1583 DFFNEGX1_34/a_23_6# 0 6.85692f **FLOATING
C1584 DFFNEGX1_34/a_34_4# 0 4.93023f **FLOATING
C1585 DFFNEGX1_34/a_2_6# 0 9.33504f **FLOATING
C1586 DFFNEGX1_12/a_66_6# 0 6.40992f **FLOATING
C1587 DFFNEGX1_12/a_23_6# 0 6.85692f **FLOATING
C1588 DFFNEGX1_12/a_34_4# 0 4.93023f **FLOATING
C1589 DFFNEGX1_12/a_2_6# 0 9.33504f **FLOATING
C1590 INVX2_150/Y 0 19.87506f **FLOATING
C1591 INVX2_38/Y 0 5.717219f **FLOATING
C1592 OAI22X1_7/a_2_6# 0 4.25172f **FLOATING
C1593 AOI22X1_56/a_2_54# 0 6.66f **FLOATING
C1594 AOI22X1_45/a_2_54# 0 6.66f **FLOATING
C1595 AOI22X1_34/a_2_54# 0 6.66f **FLOATING
C1596 AOI22X1_23/a_2_54# 0 6.66f **FLOATING
C1597 AOI22X1_12/a_2_54# 0 6.66f **FLOATING
C1598 OR2X1_17/Y 0 10.751821f **FLOATING
C1599 OAI21X1_7/C 0 11.826961f **FLOATING
C1600 NOR2X1_13/Y 0 7.97625f **FLOATING
C1601 OAI21X1_150/a_2_6# 0 2.78652f **FLOATING
C1602 AOI22X1_4/a_2_54# 0 6.66f **FLOATING
C1603 XOR2X1_20/a_2_6# 0 8.278139f **FLOATING
C1604 XOR2X1_20/a_13_43# 0 7.836241f **FLOATING
C1605 AND2X2_9/a_2_6# 0 6.03567f **FLOATING
C1606 DFFNEGX1_88/a_66_6# 0 6.40992f **FLOATING
C1607 DFFNEGX1_88/a_23_6# 0 6.85692f **FLOATING
C1608 DFFNEGX1_88/a_34_4# 0 4.93023f **FLOATING
C1609 DFFNEGX1_88/a_2_6# 0 9.33504f **FLOATING
C1610 DFFNEGX1_44/a_66_6# 0 6.40992f **FLOATING
C1611 DFFNEGX1_44/a_23_6# 0 6.85692f **FLOATING
C1612 DFFNEGX1_44/a_34_4# 0 4.93023f **FLOATING
C1613 DFFNEGX1_44/a_2_6# 0 9.33504f **FLOATING
C1614 DFFNEGX1_77/a_66_6# 0 6.40992f **FLOATING
C1615 DFFNEGX1_77/a_23_6# 0 6.85692f **FLOATING
C1616 DFFNEGX1_77/a_34_4# 0 4.93023f **FLOATING
C1617 DFFNEGX1_77/a_2_6# 0 9.33504f **FLOATING
C1618 AOI21X1_29/Y 0 15.37149f **FLOATING
C1619 DFFNEGX1_55/a_66_6# 0 6.40992f **FLOATING
C1620 DFFNEGX1_55/a_23_6# 0 6.85692f **FLOATING
C1621 DFFNEGX1_55/a_34_4# 0 4.93023f **FLOATING
C1622 DFFNEGX1_55/a_2_6# 0 9.33504f **FLOATING
C1623 NAND2X1_48/Y 0 11.963701f **FLOATING
C1624 DFFNEGX1_66/a_66_6# 0 6.40992f **FLOATING
C1625 DFFNEGX1_66/a_23_6# 0 6.85692f **FLOATING
C1626 DFFNEGX1_66/a_34_4# 0 4.93023f **FLOATING
C1627 DFFNEGX1_66/a_2_6# 0 9.33504f **FLOATING
C1628 DFFNEGX1_22/a_66_6# 0 6.40992f **FLOATING
C1629 DFFNEGX1_22/a_23_6# 0 6.85692f **FLOATING
C1630 DFFNEGX1_22/a_34_4# 0 4.93023f **FLOATING
C1631 DFFNEGX1_22/a_2_6# 0 9.33504f **FLOATING
C1632 DFFNEGX1_33/a_66_6# 0 6.40992f **FLOATING
C1633 DFFNEGX1_33/a_23_6# 0 6.85692f **FLOATING
C1634 DFFNEGX1_33/a_34_4# 0 4.93023f **FLOATING
C1635 DFFNEGX1_33/a_2_6# 0 9.33504f **FLOATING
C1636 DFFNEGX1_11/a_66_6# 0 6.40992f **FLOATING
C1637 DFFNEGX1_11/a_23_6# 0 6.85692f **FLOATING
C1638 DFFNEGX1_11/a_34_4# 0 4.93023f **FLOATING
C1639 DFFNEGX1_11/a_2_6# 0 9.33504f **FLOATING
C1640 INVX2_160/Y 0 6.01206f **FLOATING
C1641 player_left_input 0 14.31998f **FLOATING
C1642 NAND2X1_67/A 0 11.736179f **FLOATING
C1643 INVX2_48/Y 0 9.956429f **FLOATING
C1644 OAI22X1_6/a_2_6# 0 4.25172f **FLOATING
C1645 AOI22X1_55/a_2_54# 0 6.66f **FLOATING
C1646 AOI22X1_44/a_2_54# 0 6.66f **FLOATING
C1647 INVX2_96/Y 0 15.094561f **FLOATING
C1648 AOI22X1_33/a_2_54# 0 6.66f **FLOATING
C1649 AOI22X1_22/a_2_54# 0 6.66f **FLOATING
C1650 AOI22X1_11/a_2_54# 0 6.66f **FLOATING
C1651 OAI21X1_93/C 0 8.252641f **FLOATING
C1652 NAND3X1_9/Y 0 11.209169f **FLOATING
C1653 INVX2_73/A 0 13.25481f **FLOATING
C1654 AOI22X1_3/a_2_54# 0 6.66f **FLOATING
C1655 invader_2_coord_y[0] 0 65.29019f **FLOATING
C1656 AND2X2_8/a_2_6# 0 6.03567f **FLOATING
C1657 DFFNEGX1_87/a_66_6# 0 6.40992f **FLOATING
C1658 AOI22X1_47/A 0 9.57147f **FLOATING
C1659 DFFNEGX1_87/a_23_6# 0 6.85692f **FLOATING
C1660 DFFNEGX1_87/a_34_4# 0 4.93023f **FLOATING
C1661 DFFNEGX1_87/a_2_6# 0 9.33504f **FLOATING
C1662 DFFNEGX1_65/a_66_6# 0 6.40992f **FLOATING
C1663 DFFNEGX1_65/a_23_6# 0 6.85692f **FLOATING
C1664 DFFNEGX1_65/a_34_4# 0 4.93023f **FLOATING
C1665 DFFNEGX1_65/a_2_6# 0 9.33504f **FLOATING
C1666 OAI21X1_92/Y 0 13.582501f **FLOATING
C1667 DFFNEGX1_76/a_66_6# 0 6.40992f **FLOATING
C1668 DFFNEGX1_76/a_23_6# 0 6.85692f **FLOATING
C1669 DFFNEGX1_76/a_34_4# 0 4.93023f **FLOATING
C1670 DFFNEGX1_76/a_2_6# 0 9.33504f **FLOATING
C1671 DFFNEGX1_54/a_66_6# 0 6.40992f **FLOATING
C1672 DFFNEGX1_54/a_23_6# 0 6.85692f **FLOATING
C1673 DFFNEGX1_54/a_34_4# 0 4.93023f **FLOATING
C1674 DFFNEGX1_54/a_2_6# 0 9.33504f **FLOATING
C1675 DFFNEGX1_43/a_66_6# 0 6.40992f **FLOATING
C1676 DFFNEGX1_43/a_23_6# 0 6.85692f **FLOATING
C1677 DFFNEGX1_43/a_34_4# 0 4.93023f **FLOATING
C1678 DFFNEGX1_43/a_2_6# 0 9.33504f **FLOATING
C1679 OAI21X1_90/Y 0 11.724661f **FLOATING
C1680 DFFNEGX1_32/a_66_6# 0 6.40992f **FLOATING
C1681 DFFNEGX1_32/a_23_6# 0 6.85692f **FLOATING
C1682 DFFNEGX1_32/a_34_4# 0 4.93023f **FLOATING
C1683 DFFNEGX1_32/a_2_6# 0 9.33504f **FLOATING
C1684 DFFNEGX1_10/a_66_6# 0 6.40992f **FLOATING
C1685 DFFNEGX1_10/a_23_6# 0 6.85692f **FLOATING
C1686 DFFNEGX1_10/a_34_4# 0 4.93023f **FLOATING
C1687 DFFNEGX1_10/a_2_6# 0 9.33504f **FLOATING
C1688 DFFNEGX1_21/a_66_6# 0 6.40992f **FLOATING
C1689 DFFNEGX1_21/a_23_6# 0 6.85692f **FLOATING
C1690 DFFNEGX1_21/a_34_4# 0 4.93023f **FLOATING
C1691 DFFNEGX1_21/a_2_6# 0 9.33504f **FLOATING
C1692 XNOR2X1_8/a_2_6# 0 6.77121f **FLOATING
C1693 XNOR2X1_8/a_12_41# 0 7.905991f **FLOATING
C1694 INVX2_58/A 0 19.59021f **FLOATING
C1695 INVX2_69/A 0 15.00522f **FLOATING
C1696 player_bullet_coord_y[0] 0 72.15975f **FLOATING
C1697 OAI22X1_5/a_2_6# 0 4.25172f **FLOATING
C1698 INVX2_61/A 0 11.62191f **FLOATING
C1699 AOI22X1_54/a_2_54# 0 6.66f **FLOATING
C1700 AOI22X1_43/a_2_54# 0 6.66f **FLOATING
C1701 AOI22X1_32/a_2_54# 0 6.66f **FLOATING
C1702 AOI22X1_21/a_2_54# 0 6.66f **FLOATING
C1703 AOI22X1_10/a_2_54# 0 6.66f **FLOATING
C1704 OAI21X1_92/C 0 10.70784f **FLOATING
C1705 OAI21X1_55/C 0 11.69544f **FLOATING
C1706 AOI22X1_2/a_2_54# 0 6.66f **FLOATING
C1707 INVX2_40/Y 0 9.087659f **FLOATING
C1708 AND2X2_7/a_2_6# 0 6.03567f **FLOATING
C1709 DFFNEGX1_53/a_66_6# 0 6.40992f **FLOATING
C1710 DFFNEGX1_53/a_23_6# 0 6.85692f **FLOATING
C1711 DFFNEGX1_53/a_34_4# 0 4.93023f **FLOATING
C1712 DFFNEGX1_53/a_2_6# 0 9.33504f **FLOATING
C1713 DFFNEGX1_64/a_66_6# 0 6.40992f **FLOATING
C1714 DFFNEGX1_64/a_23_6# 0 6.85692f **FLOATING
C1715 DFFNEGX1_64/a_34_4# 0 4.93023f **FLOATING
C1716 DFFNEGX1_64/a_2_6# 0 9.33504f **FLOATING
C1717 DFFNEGX1_86/a_66_6# 0 6.40992f **FLOATING
C1718 DFFNEGX1_86/a_23_6# 0 6.85692f **FLOATING
C1719 DFFNEGX1_86/a_34_4# 0 4.93023f **FLOATING
C1720 DFFNEGX1_86/a_2_6# 0 9.33504f **FLOATING
C1721 DFFNEGX1_75/a_66_6# 0 6.40992f **FLOATING
C1722 DFFNEGX1_75/a_23_6# 0 6.85692f **FLOATING
C1723 DFFNEGX1_75/a_34_4# 0 4.93023f **FLOATING
C1724 DFFNEGX1_75/a_2_6# 0 9.33504f **FLOATING
C1725 DFFNEGX1_42/a_66_6# 0 6.40992f **FLOATING
C1726 DFFNEGX1_42/a_23_6# 0 6.85692f **FLOATING
C1727 DFFNEGX1_42/a_34_4# 0 4.93023f **FLOATING
C1728 DFFNEGX1_42/a_2_6# 0 9.33504f **FLOATING
C1729 DFFNEGX1_31/a_66_6# 0 6.40992f **FLOATING
C1730 DFFNEGX1_31/a_23_6# 0 6.85692f **FLOATING
C1731 DFFNEGX1_31/a_34_4# 0 4.93023f **FLOATING
C1732 DFFNEGX1_31/a_2_6# 0 9.33504f **FLOATING
C1733 DFFNEGX1_20/a_66_6# 0 6.40992f **FLOATING
C1734 DFFNEGX1_20/a_23_6# 0 6.85692f **FLOATING
C1735 DFFNEGX1_20/a_34_4# 0 4.93023f **FLOATING
C1736 DFFNEGX1_20/a_2_6# 0 9.33504f **FLOATING
C1737 NAND2X1_3/Y 0 13.136761f **FLOATING
C1738 XNOR2X1_7/a_2_6# 0 6.77121f **FLOATING
C1739 XNOR2X1_7/a_12_41# 0 7.905991f **FLOATING
C1740 NAND3X1_18/Y 0 13.27875f **FLOATING
C1741 INVX2_57/Y 0 12.552541f **FLOATING
C1742 INVX2_79/Y 0 8.8518f **FLOATING
C1743 INVX2_24/Y 0 5.60184f **FLOATING
C1744 OAI22X1_4/a_2_6# 0 4.25172f **FLOATING
C1745 AOI22X1_53/a_2_54# 0 6.66f **FLOATING
C1746 AOI22X1_31/a_2_54# 0 6.66f **FLOATING
C1747 NAND2X1_24/Y 0 12.68526f **FLOATING
C1748 AOI22X1_20/a_2_54# 0 6.66f **FLOATING
C1749 INVX2_10/Y 0 12.81036f **FLOATING
C1750 AOI22X1_42/a_2_54# 0 6.66f **FLOATING
C1751 OAI21X1_88/B 0 6.5403f **FLOATING
C1752 INVX2_102/A 0 16.392962f **FLOATING
C1753 INVX2_97/Y 0 6.615149f **FLOATING
C1754 AOI22X1_1/a_2_54# 0 6.66f **FLOATING
C1755 AND2X2_6/a_2_6# 0 6.03567f **FLOATING
C1756 DFFNEGX1_85/a_66_6# 0 6.40992f **FLOATING
C1757 DFFNEGX1_85/a_23_6# 0 6.85692f **FLOATING
C1758 DFFNEGX1_85/a_34_4# 0 4.93023f **FLOATING
C1759 DFFNEGX1_85/a_2_6# 0 9.33504f **FLOATING
C1760 DFFNEGX1_74/a_66_6# 0 6.40992f **FLOATING
C1761 DFFNEGX1_74/a_23_6# 0 6.85692f **FLOATING
C1762 DFFNEGX1_74/a_34_4# 0 4.93023f **FLOATING
C1763 DFFNEGX1_74/a_2_6# 0 9.33504f **FLOATING
C1764 DFFNEGX1_63/a_66_6# 0 6.40992f **FLOATING
C1765 DFFNEGX1_63/a_23_6# 0 6.85692f **FLOATING
C1766 DFFNEGX1_63/a_34_4# 0 4.93023f **FLOATING
C1767 DFFNEGX1_63/a_2_6# 0 9.33504f **FLOATING
C1768 DFFNEGX1_52/a_66_6# 0 6.40992f **FLOATING
C1769 DFFNEGX1_52/a_23_6# 0 6.85692f **FLOATING
C1770 DFFNEGX1_52/a_34_4# 0 4.93023f **FLOATING
C1771 DFFNEGX1_52/a_2_6# 0 9.33504f **FLOATING
C1772 DFFNEGX1_41/a_66_6# 0 6.40992f **FLOATING
C1773 DFFNEGX1_41/a_23_6# 0 6.85692f **FLOATING
C1774 DFFNEGX1_41/a_34_4# 0 4.93023f **FLOATING
C1775 DFFNEGX1_41/a_2_6# 0 9.33504f **FLOATING
C1776 DFFNEGX1_30/a_66_6# 0 6.40992f **FLOATING
C1777 DFFNEGX1_30/a_23_6# 0 6.85692f **FLOATING
C1778 DFFNEGX1_30/a_34_4# 0 4.93023f **FLOATING
C1779 DFFNEGX1_30/a_2_6# 0 9.33504f **FLOATING
C1780 XNOR2X1_6/a_2_6# 0 6.77121f **FLOATING
C1781 XNOR2X1_6/a_12_41# 0 7.905991f **FLOATING
C1782 NAND2X1_70/A 0 12.388801f **FLOATING
C1783 XNOR2X1_5/Y 0 12.81135f **FLOATING
C1784 OAI21X1_19/a_2_6# 0 2.78652f **FLOATING
C1785 OAI21X1_19/Y 0 6.91248f **FLOATING
C1786 INVX2_56/Y 0 9.919171f **FLOATING
C1787 INVX2_78/Y 0 16.078562f **FLOATING
C1788 INVX2_34/Y 0 8.024039f **FLOATING
C1789 HAX1_10/B 0 14.990881f **FLOATING
C1790 OAI22X1_3/a_2_6# 0 4.25172f **FLOATING
C1791 AOI22X1_63/a_2_54# 0 6.66f **FLOATING
C1792 AOI22X1_52/a_2_54# 0 6.66f **FLOATING
C1793 AOI22X1_30/a_2_54# 0 6.66f **FLOATING
C1794 AOI22X1_41/a_2_54# 0 6.66f **FLOATING
C1795 NAND2X1_65/Y 0 6.5403f **FLOATING
C1796 NAND3X1_7/A 0 11.506409f **FLOATING
C1797 AOI22X1_0/a_2_54# 0 6.66f **FLOATING
C1798 AND2X2_5/a_2_6# 0 6.03567f **FLOATING
C1799 INVX2_27/Y 0 10.077538f **FLOATING
C1800 HAX1_9/a_38_6# 0 2.442f **FLOATING
C1801 HAX1_9/a_41_74# 0 5.99325f **FLOATING
C1802 HAX1_9/a_2_74# 0 7.65318f **FLOATING
C1803 DFFNEGX1_84/a_66_6# 0 6.40992f **FLOATING
C1804 DFFNEGX1_84/a_23_6# 0 6.85692f **FLOATING
C1805 DFFNEGX1_84/a_34_4# 0 4.93023f **FLOATING
C1806 DFFNEGX1_84/a_2_6# 0 9.33504f **FLOATING
C1807 DFFNEGX1_73/a_66_6# 0 6.40992f **FLOATING
C1808 DFFNEGX1_73/a_23_6# 0 6.85692f **FLOATING
C1809 DFFNEGX1_73/a_34_4# 0 4.93023f **FLOATING
C1810 DFFNEGX1_73/a_2_6# 0 9.33504f **FLOATING
C1811 DFFNEGX1_62/a_66_6# 0 6.40992f **FLOATING
C1812 DFFNEGX1_62/a_23_6# 0 6.85692f **FLOATING
C1813 DFFNEGX1_62/a_34_4# 0 4.93023f **FLOATING
C1814 DFFNEGX1_62/a_2_6# 0 9.33504f **FLOATING
C1815 OAI21X1_95/Y 0 12.329821f **FLOATING
C1816 DFFNEGX1_40/a_66_6# 0 6.40992f **FLOATING
C1817 DFFNEGX1_40/a_23_6# 0 6.85692f **FLOATING
C1818 DFFNEGX1_40/a_34_4# 0 4.93023f **FLOATING
C1819 DFFNEGX1_40/a_2_6# 0 9.33504f **FLOATING
C1820 DFFNEGX1_51/a_66_6# 0 6.40992f **FLOATING
C1821 DFFNEGX1_51/a_23_6# 0 6.85692f **FLOATING
C1822 DFFNEGX1_51/a_34_4# 0 4.93023f **FLOATING
C1823 DFFNEGX1_51/a_2_6# 0 9.33504f **FLOATING
